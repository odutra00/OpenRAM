* Functional test stimulus file for 10ns period

* TT process corner
.include "/tmp/openram_odutra_1749387_temp/sram.sp"

* Global Power Supplies
Vvdd vdd 0 0.9

*Nodes gnd and 0 are the same global ground node in ngspice/hspice/xa. Otherwise, this source may be needed.
*Vgnd gnd 0 0.0

* Instantiation of the SRAM
Xsram_8b_16_1rw_tsmc65N din0_0 din0_1 din0_2 din0_3 din0_4 din0_5 din0_6 din0_7 a0_0 a0_1 a0_2 a0_3 CSB0 WEB0 clk0 dout0_0 dout0_1 dout0_2 dout0_3 dout0_4 dout0_5 dout0_6 dout0_7 vdd gnd sram_8b_16_1rw_tsmc65N

* SRAM output loads
CD00 dout0_0  0 0.02f
CD01 dout0_1  0 0.02f
CD02 dout0_2  0 0.02f
CD03 dout0_3  0 0.02f
CD04 dout0_4  0 0.02f
CD05 dout0_5  0 0.02f
CD06 dout0_6  0 0.02f
CD07 dout0_7  0 0.02f

* Important signals for debug
* bl:	xsram:xbank0:bl_0_0
* br:	xsram:xbank0:br_0_0
* s_en:	xsram:s_en
* q:	xsram:xbank0:xbitcell_array:xbitcell_array:xbit_r0_c0.Q
* qbar:	xsram:xbank0:xbitcell_array:xbitcell_array:xbit_r0_c0.Q_bar

* Sequence of operations
*	Idle during cycle 0 (0ns - 10ns)
*	Writing 01111001  to  address 1110 (from port 0) during cycle 1 (10ns - 20ns)
*	Writing 11111110  to  address 1110 (from port 0) during cycle 2 (20ns - 30ns)
*	Writing 00000100  to  address 1110 (from port 0) during cycle 3 (30ns - 40ns)
*	Reading 00000100 from address 1110 (from port 0) during cycle 4 (40ns - 50ns)
*	Writing 01110001  to  address 1110 (from port 0) during cycle 6 (60ns - 70ns)
*	Writing 10101000  to  address 0000 (from port 0) during cycle 7 (70ns - 80ns)
*	Writing 11101101  to  address 0000 (from port 0) during cycle 8 (80ns - 90ns)
*	Writing 00110110  to  address 0000 (from port 0) during cycle 9 (90ns - 100ns)
*	Reading 00110110 from address 0000 (from port 0) during cycle 11 (110ns - 120ns)
*	Reading 01110001 from address 1110 (from port 0) during cycle 13 (130ns - 140ns)
*	Writing 00101100  to  address 0000 (from port 0) during cycle 14 (140ns - 150ns)
*	Writing 01011010  to  address 1110 (from port 0) during cycle 15 (150ns - 160ns)
*	Writing 11010011  to  address 1110 (from port 0) during cycle 16 (160ns - 170ns)
*	Reading 00101100 from address 0000 (from port 0) during cycle 17 (170ns - 180ns)
*	Reading 00101100 from address 0000 (from port 0) during cycle 18 (180ns - 190ns)
*	Reading 00101100 from address 0000 (from port 0) during cycle 20 (200ns - 210ns)
*	Reading 11010011 from address 1110 (from port 0) during cycle 21 (210ns - 220ns)
*	Writing 10100011  to  address 1110 (from port 0) during cycle 22 (220ns - 230ns)
*	Reading 00101100 from address 0000 (from port 0) during cycle 23 (230ns - 240ns)
*	Reading 10100011 from address 1110 (from port 0) during cycle 24 (240ns - 250ns)
*	Reading 00101100 from address 0000 (from port 0) during cycle 25 (250ns - 260ns)
*	Reading 00101100 from address 0000 (from port 0) during cycle 26 (260ns - 270ns)
*	Reading 10100011 from address 1110 (from port 0) during cycle 29 (290ns - 300ns)
*	Reading 10100011 from address 1110 (from port 0) during cycle 30 (300ns - 310ns)
*	Reading 00101100 from address 0000 (from port 0) during cycle 32 (320ns - 330ns)
*	Reading 00101100 from address 0000 (from port 0) during cycle 33 (330ns - 340ns)
*	Reading 00101100 from address 0000 (from port 0) during cycle 35 (350ns - 360ns)
*	Reading 10100011 from address 1110 (from port 0) during cycle 37 (370ns - 380ns)
*	Reading 00101100 from address 0000 (from port 0) during cycle 38 (380ns - 390ns)
*	Reading 00101100 from address 0000 (from port 0) during cycle 39 (390ns - 400ns)
*	Writing 00100010  to  address 0000 (from port 0) during cycle 40 (400ns - 410ns)
*	Writing 10010001  to  address 1110 (from port 0) during cycle 42 (420ns - 430ns)
*	Reading 10010001 from address 1110 (from port 0) during cycle 43 (430ns - 440ns)
*	Reading 10010001 from address 1110 (from port 0) during cycle 44 (440ns - 450ns)
*	Writing 10010111  to  address 0000 (from port 0) during cycle 45 (450ns - 460ns)
*	Reading 10010111 from address 0000 (from port 0) during cycle 47 (470ns - 480ns)
*	Reading 10010001 from address 1110 (from port 0) during cycle 48 (480ns - 490ns)
*	Writing 10001101  to  address 0000 (from port 0) during cycle 49 (490ns - 500ns)
*	Writing 01111000  to  address 1110 (from port 0) during cycle 50 (500ns - 510ns)
*	Reading 10001101 from address 0000 (from port 0) during cycle 52 (520ns - 530ns)
*	Writing 10110101  to  address 0000 (from port 0) during cycle 54 (540ns - 550ns)
*	Reading 01111000 from address 1110 (from port 0) during cycle 57 (570ns - 580ns)
*	Reading 01111000 from address 1110 (from port 0) during cycle 58 (580ns - 590ns)
*	Reading 10110101 from address 0000 (from port 0) during cycle 59 (590ns - 600ns)
*	Reading 01111000 from address 1110 (from port 0) during cycle 60 (600ns - 610ns)
*	Writing 01100111  to  address 0000 (from port 0) during cycle 61 (610ns - 620ns)
*	Reading 01111000 from address 1110 (from port 0) during cycle 62 (620ns - 630ns)
*	Writing 00110100  to  address 1110 (from port 0) during cycle 64 (640ns - 650ns)
*	Writing 01000011  to  address 1110 (from port 0) during cycle 66 (660ns - 670ns)
*	Writing 00001101  to  address 0000 (from port 0) during cycle 70 (700ns - 710ns)
*	Writing 00011001  to  address 0000 (from port 0) during cycle 71 (710ns - 720ns)
*	Reading 00011001 from address 0000 (from port 0) during cycle 72 (720ns - 730ns)
*	Reading 00011001 from address 0000 (from port 0) during cycle 74 (740ns - 750ns)
*	Reading 00011001 from address 0000 (from port 0) during cycle 75 (750ns - 760ns)
*	Reading 01000011 from address 1110 (from port 0) during cycle 77 (770ns - 780ns)
*	Reading 01000011 from address 1110 (from port 0) during cycle 78 (780ns - 790ns)
*	Writing 01011000  to  address 0000 (from port 0) during cycle 79 (790ns - 800ns)
*	Writing 00000001  to  address 0000 (from port 0) during cycle 80 (800ns - 810ns)
*	Writing 10011101  to  address 0000 (from port 0) during cycle 81 (810ns - 820ns)
*	Reading 10011101 from address 0000 (from port 0) during cycle 82 (820ns - 830ns)
*	Reading 10011101 from address 0000 (from port 0) during cycle 83 (830ns - 840ns)
*	Writing 10110000  to  address 0000 (from port 0) during cycle 86 (860ns - 870ns)
*	Reading 01000011 from address 1110 (from port 0) during cycle 87 (870ns - 880ns)
*	Writing 01011011  to  address 1110 (from port 0) during cycle 89 (890ns - 900ns)
*	Reading 01011011 from address 1110 (from port 0) during cycle 90 (900ns - 910ns)
*	Writing 10111111  to  address 1110 (from port 0) during cycle 91 (910ns - 920ns)
*	Reading 10110000 from address 0000 (from port 0) during cycle 93 (930ns - 940ns)
*	Writing 11010111  to  address 1110 (from port 0) during cycle 94 (940ns - 950ns)
*	Reading 10110000 from address 0000 (from port 0) during cycle 95 (950ns - 960ns)
*	Writing 01010111  to  address 0000 (from port 0) during cycle 96 (960ns - 970ns)
*	Reading 11010111 from address 1110 (from port 0) during cycle 97 (970ns - 980ns)
*	Reading 01010111 from address 0000 (from port 0) during cycle 98 (980ns - 990ns)
*	Writing 10111010  to  address 1110 (from port 0) during cycle 99 (990ns - 1000ns)
*	Writing 11001010  to  address 0000 (from port 0) during cycle 100 (1000ns - 1010ns)
*	Writing 11001101  to  address 1110 (from port 0) during cycle 101 (1010ns - 1020ns)
*	Reading 11001101 from address 1110 (from port 0) during cycle 104 (1040ns - 1050ns)
*	Reading 11001010 from address 0000 (from port 0) during cycle 105 (1050ns - 1060ns)
*	Writing 00001111  to  address 1110 (from port 0) during cycle 106 (1060ns - 1070ns)
*	Reading 11001010 from address 0000 (from port 0) during cycle 107 (1070ns - 1080ns)
*	Reading 00001111 from address 1110 (from port 0) during cycle 109 (1090ns - 1100ns)
*	Reading 11001010 from address 0000 (from port 0) during cycle 110 (1100ns - 1110ns)
*	Reading 11001010 from address 0000 (from port 0) during cycle 111 (1110ns - 1120ns)
*	Reading 00001111 from address 1110 (from port 0) during cycle 112 (1120ns - 1130ns)
*	Reading 11001010 from address 0000 (from port 0) during cycle 113 (1130ns - 1140ns)
*	Reading 11001010 from address 0000 (from port 0) during cycle 114 (1140ns - 1150ns)
*	Reading 00001111 from address 1110 (from port 0) during cycle 115 (1150ns - 1160ns)
*	Reading 00001111 from address 1110 (from port 0) during cycle 116 (1160ns - 1170ns)
*	Reading 11001010 from address 0000 (from port 0) during cycle 118 (1180ns - 1190ns)
*	Reading 00001111 from address 1110 (from port 0) during cycle 119 (1190ns - 1200ns)
*	Reading 11001010 from address 0000 (from port 0) during cycle 121 (1210ns - 1220ns)
*	Writing 10010000  to  address 1110 (from port 0) during cycle 123 (1230ns - 1240ns)
*	Writing 10001100  to  address 1110 (from port 0) during cycle 124 (1240ns - 1250ns)
*	Writing 10001011  to  address 0000 (from port 0) during cycle 125 (1250ns - 1260ns)
*	Reading 10001100 from address 1110 (from port 0) during cycle 126 (1260ns - 1270ns)
*	Writing 00011000  to  address 0000 (from port 0) during cycle 129 (1290ns - 1300ns)
*	Writing 10011010  to  address 0000 (from port 0) during cycle 130 (1300ns - 1310ns)
*	Writing 10011100  to  address 0000 (from port 0) during cycle 131 (1310ns - 1320ns)
*	Writing 11100100  to  address 1110 (from port 0) during cycle 133 (1330ns - 1340ns)
*	Reading 11100100 from address 1110 (from port 0) during cycle 134 (1340ns - 1350ns)
*	Writing 11110001  to  address 1110 (from port 0) during cycle 135 (1350ns - 1360ns)
*	Reading 11110001 from address 1110 (from port 0) during cycle 136 (1360ns - 1370ns)
*	Writing 01100101  to  address 0000 (from port 0) during cycle 137 (1370ns - 1380ns)
*	Reading 01100101 from address 0000 (from port 0) during cycle 139 (1390ns - 1400ns)
*	Reading 11110001 from address 1110 (from port 0) during cycle 140 (1400ns - 1410ns)
*	Reading 01100101 from address 0000 (from port 0) during cycle 142 (1420ns - 1430ns)
*	Reading 11110001 from address 1110 (from port 0) during cycle 143 (1430ns - 1440ns)
*	Reading 01100101 from address 0000 (from port 0) during cycle 144 (1440ns - 1450ns)
*	Reading 11110001 from address 1110 (from port 0) during cycle 145 (1450ns - 1460ns)
*	Writing 11011011  to  address 1110 (from port 0) during cycle 146 (1460ns - 1470ns)
*	Writing 00001010  to  address 0000 (from port 0) during cycle 147 (1470ns - 1480ns)
*	Reading 11011011 from address 1110 (from port 0) during cycle 148 (1480ns - 1490ns)
*	Reading 00001010 from address 0000 (from port 0) during cycle 149 (1490ns - 1500ns)
*	Reading 11011011 from address 1110 (from port 0) during cycle 150 (1500ns - 1510ns)
*	Reading 00001010 from address 0000 (from port 0) during cycle 151 (1510ns - 1520ns)
*	Reading 00001010 from address 0000 (from port 0) during cycle 152 (1520ns - 1530ns)
*	Writing 01100110  to  address 1110 (from port 0) during cycle 155 (1550ns - 1560ns)
*	Reading 00001010 from address 0000 (from port 0) during cycle 156 (1560ns - 1570ns)
*	Reading 01100110 from address 1110 (from port 0) during cycle 157 (1570ns - 1580ns)
*	Reading 01100110 from address 1110 (from port 0) during cycle 158 (1580ns - 1590ns)
*	Reading 01100110 from address 1110 (from port 0) during cycle 159 (1590ns - 1600ns)
*	Reading 01100110 from address 1110 (from port 0) during cycle 160 (1600ns - 1610ns)
*	Writing 01111110  to  address 1110 (from port 0) during cycle 162 (1620ns - 1630ns)
*	Reading 01111110 from address 1110 (from port 0) during cycle 163 (1630ns - 1640ns)
*	Reading 01111110 from address 1110 (from port 0) during cycle 165 (1650ns - 1660ns)
*	Reading 00001010 from address 0000 (from port 0) during cycle 166 (1660ns - 1670ns)
*	Reading 01111110 from address 1110 (from port 0) during cycle 168 (1680ns - 1690ns)
*	Reading 01111110 from address 1110 (from port 0) during cycle 169 (1690ns - 1700ns)
*	Reading 01111110 from address 1110 (from port 0) during cycle 171 (1710ns - 1720ns)
*	Writing 00111110  to  address 1110 (from port 0) during cycle 172 (1720ns - 1730ns)
*	Reading 00001010 from address 0000 (from port 0) during cycle 175 (1750ns - 1760ns)
*	Reading 00111110 from address 1110 (from port 0) during cycle 176 (1760ns - 1770ns)
*	Writing 11010011  to  address 1110 (from port 0) during cycle 177 (1770ns - 1780ns)
*	Reading 00001010 from address 0000 (from port 0) during cycle 179 (1790ns - 1800ns)
*	Reading 11010011 from address 1110 (from port 0) during cycle 180 (1800ns - 1810ns)
*	Reading 11010011 from address 1110 (from port 0) during cycle 182 (1820ns - 1830ns)
*	Reading 00001010 from address 0000 (from port 0) during cycle 183 (1830ns - 1840ns)
*	Reading 11010011 from address 1110 (from port 0) during cycle 184 (1840ns - 1850ns)
*	Writing 00000111  to  address 1110 (from port 0) during cycle 185 (1850ns - 1860ns)
*	Reading 00001010 from address 0000 (from port 0) during cycle 186 (1860ns - 1870ns)
*	Reading 00001010 from address 0000 (from port 0) during cycle 187 (1870ns - 1880ns)
*	Reading 00001010 from address 0000 (from port 0) during cycle 188 (1880ns - 1890ns)
*	Writing 01110010  to  address 0000 (from port 0) during cycle 189 (1890ns - 1900ns)
*	Reading 01110010 from address 0000 (from port 0) during cycle 190 (1900ns - 1910ns)
*	Writing 11100101  to  address 1110 (from port 0) during cycle 191 (1910ns - 1920ns)
*	Writing 11100100  to  address 1110 (from port 0) during cycle 192 (1920ns - 1930ns)
*	Writing 10000011  to  address 0000 (from port 0) during cycle 194 (1940ns - 1950ns)
*	Reading 11100100 from address 1110 (from port 0) during cycle 195 (1950ns - 1960ns)
*	Reading 11100100 from address 1110 (from port 0) during cycle 196 (1960ns - 1970ns)
*	Reading 10000011 from address 0000 (from port 0) during cycle 197 (1970ns - 1980ns)
*	Reading 10000011 from address 0000 (from port 0) during cycle 199 (1990ns - 2000ns)
*	Reading 10000011 from address 0000 (from port 0) during cycle 200 (2000ns - 2010ns)
*	Reading 11100100 from address 1110 (from port 0) during cycle 201 (2010ns - 2020ns)
*	Reading 11100100 from address 1110 (from port 0) during cycle 203 (2030ns - 2040ns)
*	Idle during cycle 205 (2050ns - 2060ns)

* Generation of data and address signals
* (time, data): [(0, 0), (10, 1), (20, 0), (30, 0), (40, 0), (50, 0), (60, 1), (70, 0), (80, 1), (90, 0), (100, 0), (110, 0), (120, 0), (130, 0), (140, 0), (150, 0), (160, 1), (170, 1), (180, 1), (190, 1), (200, 1), (210, 1), (220, 1), (230, 1), (240, 1), (250, 1), (260, 1), (270, 1), (280, 1), (290, 1), (300, 1), (310, 1), (320, 1), (330, 1), (340, 1), (350, 1), (360, 1), (370, 1), (380, 1), (390, 1), (400, 0), (410, 0), (420, 1), (430, 1), (440, 1), (450, 1), (460, 1), (470, 1), (480, 1), (490, 1), (500, 0), (510, 0), (520, 0), (530, 0), (540, 1), (550, 1), (560, 1), (570, 1), (580, 1), (590, 1), (600, 1), (610, 1), (620, 1), (630, 1), (640, 0), (650, 0), (660, 1), (670, 1), (680, 1), (690, 1), (700, 1), (710, 1), (720, 1), (730, 1), (740, 1), (750, 1), (760, 1), (770, 1), (780, 1), (790, 0), (800, 1), (810, 1), (820, 1), (830, 1), (840, 1), (850, 1), (860, 0), (870, 0), (880, 0), (890, 1), (900, 1), (910, 1), (920, 1), (930, 1), (940, 1), (950, 1), (960, 1), (970, 1), (980, 1), (990, 0), (1000, 0), (1010, 1), (1020, 1), (1030, 1), (1040, 1), (1050, 1), (1060, 1), (1070, 1), (1080, 1), (1090, 1), (1100, 1), (1110, 1), (1120, 1), (1130, 1), (1140, 1), (1150, 1), (1160, 1), (1170, 1), (1180, 1), (1190, 1), (1200, 1), (1210, 1), (1220, 1), (1230, 0), (1240, 0), (1250, 1), (1260, 1), (1270, 1), (1280, 1), (1290, 0), (1300, 0), (1310, 0), (1320, 0), (1330, 0), (1340, 0), (1350, 1), (1360, 1), (1370, 1), (1380, 1), (1390, 1), (1400, 1), (1410, 1), (1420, 1), (1430, 1), (1440, 1), (1450, 1), (1460, 1), (1470, 0), (1480, 0), (1490, 0), (1500, 0), (1510, 0), (1520, 0), (1530, 0), (1540, 0), (1550, 0), (1560, 0), (1570, 0), (1580, 0), (1590, 0), (1600, 0), (1610, 0), (1620, 0), (1630, 0), (1640, 0), (1650, 0), (1660, 0), (1670, 0), (1680, 0), (1690, 0), (1700, 0), (1710, 0), (1720, 0), (1730, 0), (1740, 0), (1750, 0), (1760, 0), (1770, 1), (1780, 1), (1790, 1), (1800, 1), (1810, 1), (1820, 1), (1830, 1), (1840, 1), (1850, 1), (1860, 1), (1870, 1), (1880, 1), (1890, 0), (1900, 0), (1910, 1), (1920, 0), (1930, 0), (1940, 1), (1950, 1), (1960, 1), (1970, 1), (1980, 1), (1990, 1), (2000, 1), (2010, 1), (2020, 1), (2030, 1), (2040, 1), (2050, 1)]
Vdin0_0  din0_0  0 PWL (0n 0.0v 9.45n 0.0v 9.55n 0.9v 19.45n 0.9v 19.55n 0.0v 29.45n 0.0v 29.55n 0.0v 39.45n 0.0v 39.55n 0.0v 49.45n 0.0v 49.55n 0.0v 59.45n 0.0v 59.55n 0.9v 69.45n 0.9v 69.55n 0.0v 79.45n 0.0v 79.55n 0.9v 89.45n 0.9v 89.55n 0.0v 99.45n 0.0v 99.55n 0.0v 109.45n 0.0v 109.55n 0.0v 119.45n 0.0v 119.55n 0.0v 129.45n 0.0v 129.55n 0.0v 139.45n 0.0v 139.55n 0.0v 149.45n 0.0v 149.55n 0.0v 159.45n 0.0v 159.55n 0.9v 169.45n 0.9v 169.55n 0.9v 179.45n 0.9v 179.55n 0.9v 189.45n 0.9v 189.55n 0.9v 199.45n 0.9v 199.55n 0.9v 209.45n 0.9v 209.55n 0.9v 219.45n 0.9v 219.55n 0.9v 229.45n 0.9v 229.55n 0.9v 239.45n 0.9v 239.55n 0.9v 249.45n 0.9v 249.55n 0.9v 259.45n 0.9v 259.55n 0.9v 269.45n 0.9v 269.55n 0.9v 279.45n 0.9v 279.55n 0.9v 289.45n 0.9v 289.55n 0.9v 299.45n 0.9v 299.55n 0.9v 309.45n 0.9v 309.55n 0.9v 319.45n 0.9v 319.55n 0.9v 329.45n 0.9v 329.55n 0.9v 339.45n 0.9v 339.55n 0.9v 349.45n 0.9v 349.55n 0.9v 359.45n 0.9v 359.55n 0.9v 369.45n 0.9v 369.55n 0.9v 379.45n 0.9v 379.55n 0.9v 389.45n 0.9v 389.55n 0.9v 399.45n 0.9v 399.55n 0.0v 409.45n 0.0v 409.55n 0.0v 419.45n 0.0v 419.55n 0.9v 429.45n 0.9v 429.55n 0.9v 439.45n 0.9v 439.55n 0.9v 449.45n 0.9v 449.55n 0.9v 459.45n 0.9v 459.55n 0.9v 469.45n 0.9v 469.55n 0.9v 479.45n 0.9v 479.55n 0.9v 489.45n 0.9v 489.55n 0.9v 499.45n 0.9v 499.55n 0.0v 509.45n 0.0v 509.55n 0.0v 519.45n 0.0v 519.55n 0.0v 529.45n 0.0v 529.55n 0.0v 539.45n 0.0v 539.55n 0.9v 549.45n 0.9v 549.55n 0.9v 559.45n 0.9v 559.55n 0.9v 569.45n 0.9v 569.55n 0.9v 579.45n 0.9v 579.55n 0.9v 589.45n 0.9v 589.55n 0.9v 599.45n 0.9v 599.55n 0.9v 609.45n 0.9v 609.55n 0.9v 619.45n 0.9v 619.55n 0.9v 629.45n 0.9v 629.55n 0.9v 639.45n 0.9v 639.55n 0.0v 649.45n 0.0v 649.55n 0.0v 659.45n 0.0v 659.55n 0.9v 669.45n 0.9v 669.55n 0.9v 679.45n 0.9v 679.55n 0.9v 689.45n 0.9v 689.55n 0.9v 699.45n 0.9v 699.55n 0.9v 709.45n 0.9v 709.55n 0.9v 719.45n 0.9v 719.55n 0.9v 729.45n 0.9v 729.55n 0.9v 739.45n 0.9v 739.55n 0.9v 749.45n 0.9v 749.55n 0.9v 759.45n 0.9v 759.55n 0.9v 769.45n 0.9v 769.55n 0.9v 779.45n 0.9v 779.55n 0.9v 789.45n 0.9v 789.55n 0.0v 799.45n 0.0v 799.55n 0.9v 809.45n 0.9v 809.55n 0.9v 819.45n 0.9v 819.55n 0.9v 829.45n 0.9v 829.55n 0.9v 839.45n 0.9v 839.55n 0.9v 849.45n 0.9v 849.55n 0.9v 859.45n 0.9v 859.55n 0.0v 869.45n 0.0v 869.55n 0.0v 879.45n 0.0v 879.55n 0.0v 889.45n 0.0v 889.55n 0.9v 899.45n 0.9v 899.55n 0.9v 909.45n 0.9v 909.55n 0.9v 919.45n 0.9v 919.55n 0.9v 929.45n 0.9v 929.55n 0.9v 939.45n 0.9v 939.55n 0.9v 949.45n 0.9v 949.55n 0.9v 959.45n 0.9v 959.55n 0.9v 969.45n 0.9v 969.55n 0.9v 979.45n 0.9v 979.55n 0.9v 989.45n 0.9v 989.55n 0.0v 999.45n 0.0v 999.55n 0.0v 1009.45n 0.0v 1009.55n 0.9v 1019.45n 0.9v 1019.55n 0.9v 1029.45n 0.9v 1029.55n 0.9v 1039.45n 0.9v 1039.55n 0.9v 1049.45n 0.9v 1049.55n 0.9v 1059.45n 0.9v 1059.55n 0.9v 1069.45n 0.9v 1069.55n 0.9v 1079.45n 0.9v 1079.55n 0.9v 1089.45n 0.9v 1089.55n 0.9v 1099.45n 0.9v 1099.55n 0.9v 1109.45n 0.9v 1109.55n 0.9v 1119.45n 0.9v 1119.55n 0.9v 1129.45n 0.9v 1129.55n 0.9v 1139.45n 0.9v 1139.55n 0.9v 1149.45n 0.9v 1149.55n 0.9v 1159.45n 0.9v 1159.55n 0.9v 1169.45n 0.9v 1169.55n 0.9v 1179.45n 0.9v 1179.55n 0.9v 1189.45n 0.9v 1189.55n 0.9v 1199.45n 0.9v 1199.55n 0.9v 1209.45n 0.9v 1209.55n 0.9v 1219.45n 0.9v 1219.55n 0.9v 1229.45n 0.9v 1229.55n 0.0v 1239.45n 0.0v 1239.55n 0.0v 1249.45n 0.0v 1249.55n 0.9v 1259.45n 0.9v 1259.55n 0.9v 1269.45n 0.9v 1269.55n 0.9v 1279.45n 0.9v 1279.55n 0.9v 1289.45n 0.9v 1289.55n 0.0v 1299.45n 0.0v 1299.55n 0.0v 1309.45n 0.0v 1309.55n 0.0v 1319.45n 0.0v 1319.55n 0.0v 1329.45n 0.0v 1329.55n 0.0v 1339.45n 0.0v 1339.55n 0.0v 1349.45n 0.0v 1349.55n 0.9v 1359.45n 0.9v 1359.55n 0.9v 1369.45n 0.9v 1369.55n 0.9v 1379.45n 0.9v 1379.55n 0.9v 1389.45n 0.9v 1389.55n 0.9v 1399.45n 0.9v 1399.55n 0.9v 1409.45n 0.9v 1409.55n 0.9v 1419.45n 0.9v 1419.55n 0.9v 1429.45n 0.9v 1429.55n 0.9v 1439.45n 0.9v 1439.55n 0.9v 1449.45n 0.9v 1449.55n 0.9v 1459.45n 0.9v 1459.55n 0.9v 1469.45n 0.9v 1469.55n 0.0v 1479.45n 0.0v 1479.55n 0.0v 1489.45n 0.0v 1489.55n 0.0v 1499.45n 0.0v 1499.55n 0.0v 1509.45n 0.0v 1509.55n 0.0v 1519.45n 0.0v 1519.55n 0.0v 1529.45n 0.0v 1529.55n 0.0v 1539.45n 0.0v 1539.55n 0.0v 1549.45n 0.0v 1549.55n 0.0v 1559.45n 0.0v 1559.55n 0.0v 1569.45n 0.0v 1569.55n 0.0v 1579.45n 0.0v 1579.55n 0.0v 1589.45n 0.0v 1589.55n 0.0v 1599.45n 0.0v 1599.55n 0.0v 1609.45n 0.0v 1609.55n 0.0v 1619.45n 0.0v 1619.55n 0.0v 1629.45n 0.0v 1629.55n 0.0v 1639.45n 0.0v 1639.55n 0.0v 1649.45n 0.0v 1649.55n 0.0v 1659.45n 0.0v 1659.55n 0.0v 1669.45n 0.0v 1669.55n 0.0v 1679.45n 0.0v 1679.55n 0.0v 1689.45n 0.0v 1689.55n 0.0v 1699.45n 0.0v 1699.55n 0.0v 1709.45n 0.0v 1709.55n 0.0v 1719.45n 0.0v 1719.55n 0.0v 1729.45n 0.0v 1729.55n 0.0v 1739.45n 0.0v 1739.55n 0.0v 1749.45n 0.0v 1749.55n 0.0v 1759.45n 0.0v 1759.55n 0.0v 1769.45n 0.0v 1769.55n 0.9v 1779.45n 0.9v 1779.55n 0.9v 1789.45n 0.9v 1789.55n 0.9v 1799.45n 0.9v 1799.55n 0.9v 1809.45n 0.9v 1809.55n 0.9v 1819.45n 0.9v 1819.55n 0.9v 1829.45n 0.9v 1829.55n 0.9v 1839.45n 0.9v 1839.55n 0.9v 1849.45n 0.9v 1849.55n 0.9v 1859.45n 0.9v 1859.55n 0.9v 1869.45n 0.9v 1869.55n 0.9v 1879.45n 0.9v 1879.55n 0.9v 1889.45n 0.9v 1889.55n 0.0v 1899.45n 0.0v 1899.55n 0.0v 1909.45n 0.0v 1909.55n 0.9v 1919.45n 0.9v 1919.55n 0.0v 1929.45n 0.0v 1929.55n 0.0v 1939.45n 0.0v 1939.55n 0.9v 1949.45n 0.9v 1949.55n 0.9v 1959.45n 0.9v 1959.55n 0.9v 1969.45n 0.9v 1969.55n 0.9v 1979.45n 0.9v 1979.55n 0.9v 1989.45n 0.9v 1989.55n 0.9v 1999.45n 0.9v 1999.55n 0.9v 2009.45n 0.9v 2009.55n 0.9v 2019.45n 0.9v 2019.55n 0.9v 2029.45n 0.9v 2029.55n 0.9v 2039.45n 0.9v 2039.55n 0.9v 2049.45n 0.9v 2049.55n 0.9v )
* (time, data): [(0, 0), (10, 0), (20, 1), (30, 0), (40, 0), (50, 0), (60, 0), (70, 0), (80, 0), (90, 1), (100, 1), (110, 1), (120, 1), (130, 1), (140, 0), (150, 1), (160, 1), (170, 1), (180, 1), (190, 1), (200, 1), (210, 1), (220, 1), (230, 1), (240, 1), (250, 1), (260, 1), (270, 1), (280, 1), (290, 1), (300, 1), (310, 1), (320, 1), (330, 1), (340, 1), (350, 1), (360, 1), (370, 1), (380, 1), (390, 1), (400, 1), (410, 1), (420, 0), (430, 0), (440, 0), (450, 1), (460, 1), (470, 1), (480, 1), (490, 0), (500, 0), (510, 0), (520, 0), (530, 0), (540, 0), (550, 0), (560, 0), (570, 0), (580, 0), (590, 0), (600, 0), (610, 1), (620, 1), (630, 1), (640, 0), (650, 0), (660, 1), (670, 1), (680, 1), (690, 1), (700, 0), (710, 0), (720, 0), (730, 0), (740, 0), (750, 0), (760, 0), (770, 0), (780, 0), (790, 0), (800, 0), (810, 0), (820, 0), (830, 0), (840, 0), (850, 0), (860, 0), (870, 0), (880, 0), (890, 1), (900, 1), (910, 1), (920, 1), (930, 1), (940, 1), (950, 1), (960, 1), (970, 1), (980, 1), (990, 1), (1000, 1), (1010, 0), (1020, 0), (1030, 0), (1040, 0), (1050, 0), (1060, 1), (1070, 1), (1080, 1), (1090, 1), (1100, 1), (1110, 1), (1120, 1), (1130, 1), (1140, 1), (1150, 1), (1160, 1), (1170, 1), (1180, 1), (1190, 1), (1200, 1), (1210, 1), (1220, 1), (1230, 0), (1240, 0), (1250, 1), (1260, 1), (1270, 1), (1280, 1), (1290, 0), (1300, 1), (1310, 0), (1320, 0), (1330, 0), (1340, 0), (1350, 0), (1360, 0), (1370, 0), (1380, 0), (1390, 0), (1400, 0), (1410, 0), (1420, 0), (1430, 0), (1440, 0), (1450, 0), (1460, 1), (1470, 1), (1480, 1), (1490, 1), (1500, 1), (1510, 1), (1520, 1), (1530, 1), (1540, 1), (1550, 1), (1560, 1), (1570, 1), (1580, 1), (1590, 1), (1600, 1), (1610, 1), (1620, 1), (1630, 1), (1640, 1), (1650, 1), (1660, 1), (1670, 1), (1680, 1), (1690, 1), (1700, 1), (1710, 1), (1720, 1), (1730, 1), (1740, 1), (1750, 1), (1760, 1), (1770, 1), (1780, 1), (1790, 1), (1800, 1), (1810, 1), (1820, 1), (1830, 1), (1840, 1), (1850, 1), (1860, 1), (1870, 1), (1880, 1), (1890, 1), (1900, 1), (1910, 0), (1920, 0), (1930, 0), (1940, 1), (1950, 1), (1960, 1), (1970, 1), (1980, 1), (1990, 1), (2000, 1), (2010, 1), (2020, 1), (2030, 1), (2040, 1), (2050, 1)]
Vdin0_1  din0_1  0 PWL (0n 0.0v 9.45n 0.0v 9.55n 0.0v 19.45n 0.0v 19.55n 0.9v 29.45n 0.9v 29.55n 0.0v 39.45n 0.0v 39.55n 0.0v 49.45n 0.0v 49.55n 0.0v 59.45n 0.0v 59.55n 0.0v 69.45n 0.0v 69.55n 0.0v 79.45n 0.0v 79.55n 0.0v 89.45n 0.0v 89.55n 0.9v 99.45n 0.9v 99.55n 0.9v 109.45n 0.9v 109.55n 0.9v 119.45n 0.9v 119.55n 0.9v 129.45n 0.9v 129.55n 0.9v 139.45n 0.9v 139.55n 0.0v 149.45n 0.0v 149.55n 0.9v 159.45n 0.9v 159.55n 0.9v 169.45n 0.9v 169.55n 0.9v 179.45n 0.9v 179.55n 0.9v 189.45n 0.9v 189.55n 0.9v 199.45n 0.9v 199.55n 0.9v 209.45n 0.9v 209.55n 0.9v 219.45n 0.9v 219.55n 0.9v 229.45n 0.9v 229.55n 0.9v 239.45n 0.9v 239.55n 0.9v 249.45n 0.9v 249.55n 0.9v 259.45n 0.9v 259.55n 0.9v 269.45n 0.9v 269.55n 0.9v 279.45n 0.9v 279.55n 0.9v 289.45n 0.9v 289.55n 0.9v 299.45n 0.9v 299.55n 0.9v 309.45n 0.9v 309.55n 0.9v 319.45n 0.9v 319.55n 0.9v 329.45n 0.9v 329.55n 0.9v 339.45n 0.9v 339.55n 0.9v 349.45n 0.9v 349.55n 0.9v 359.45n 0.9v 359.55n 0.9v 369.45n 0.9v 369.55n 0.9v 379.45n 0.9v 379.55n 0.9v 389.45n 0.9v 389.55n 0.9v 399.45n 0.9v 399.55n 0.9v 409.45n 0.9v 409.55n 0.9v 419.45n 0.9v 419.55n 0.0v 429.45n 0.0v 429.55n 0.0v 439.45n 0.0v 439.55n 0.0v 449.45n 0.0v 449.55n 0.9v 459.45n 0.9v 459.55n 0.9v 469.45n 0.9v 469.55n 0.9v 479.45n 0.9v 479.55n 0.9v 489.45n 0.9v 489.55n 0.0v 499.45n 0.0v 499.55n 0.0v 509.45n 0.0v 509.55n 0.0v 519.45n 0.0v 519.55n 0.0v 529.45n 0.0v 529.55n 0.0v 539.45n 0.0v 539.55n 0.0v 549.45n 0.0v 549.55n 0.0v 559.45n 0.0v 559.55n 0.0v 569.45n 0.0v 569.55n 0.0v 579.45n 0.0v 579.55n 0.0v 589.45n 0.0v 589.55n 0.0v 599.45n 0.0v 599.55n 0.0v 609.45n 0.0v 609.55n 0.9v 619.45n 0.9v 619.55n 0.9v 629.45n 0.9v 629.55n 0.9v 639.45n 0.9v 639.55n 0.0v 649.45n 0.0v 649.55n 0.0v 659.45n 0.0v 659.55n 0.9v 669.45n 0.9v 669.55n 0.9v 679.45n 0.9v 679.55n 0.9v 689.45n 0.9v 689.55n 0.9v 699.45n 0.9v 699.55n 0.0v 709.45n 0.0v 709.55n 0.0v 719.45n 0.0v 719.55n 0.0v 729.45n 0.0v 729.55n 0.0v 739.45n 0.0v 739.55n 0.0v 749.45n 0.0v 749.55n 0.0v 759.45n 0.0v 759.55n 0.0v 769.45n 0.0v 769.55n 0.0v 779.45n 0.0v 779.55n 0.0v 789.45n 0.0v 789.55n 0.0v 799.45n 0.0v 799.55n 0.0v 809.45n 0.0v 809.55n 0.0v 819.45n 0.0v 819.55n 0.0v 829.45n 0.0v 829.55n 0.0v 839.45n 0.0v 839.55n 0.0v 849.45n 0.0v 849.55n 0.0v 859.45n 0.0v 859.55n 0.0v 869.45n 0.0v 869.55n 0.0v 879.45n 0.0v 879.55n 0.0v 889.45n 0.0v 889.55n 0.9v 899.45n 0.9v 899.55n 0.9v 909.45n 0.9v 909.55n 0.9v 919.45n 0.9v 919.55n 0.9v 929.45n 0.9v 929.55n 0.9v 939.45n 0.9v 939.55n 0.9v 949.45n 0.9v 949.55n 0.9v 959.45n 0.9v 959.55n 0.9v 969.45n 0.9v 969.55n 0.9v 979.45n 0.9v 979.55n 0.9v 989.45n 0.9v 989.55n 0.9v 999.45n 0.9v 999.55n 0.9v 1009.45n 0.9v 1009.55n 0.0v 1019.45n 0.0v 1019.55n 0.0v 1029.45n 0.0v 1029.55n 0.0v 1039.45n 0.0v 1039.55n 0.0v 1049.45n 0.0v 1049.55n 0.0v 1059.45n 0.0v 1059.55n 0.9v 1069.45n 0.9v 1069.55n 0.9v 1079.45n 0.9v 1079.55n 0.9v 1089.45n 0.9v 1089.55n 0.9v 1099.45n 0.9v 1099.55n 0.9v 1109.45n 0.9v 1109.55n 0.9v 1119.45n 0.9v 1119.55n 0.9v 1129.45n 0.9v 1129.55n 0.9v 1139.45n 0.9v 1139.55n 0.9v 1149.45n 0.9v 1149.55n 0.9v 1159.45n 0.9v 1159.55n 0.9v 1169.45n 0.9v 1169.55n 0.9v 1179.45n 0.9v 1179.55n 0.9v 1189.45n 0.9v 1189.55n 0.9v 1199.45n 0.9v 1199.55n 0.9v 1209.45n 0.9v 1209.55n 0.9v 1219.45n 0.9v 1219.55n 0.9v 1229.45n 0.9v 1229.55n 0.0v 1239.45n 0.0v 1239.55n 0.0v 1249.45n 0.0v 1249.55n 0.9v 1259.45n 0.9v 1259.55n 0.9v 1269.45n 0.9v 1269.55n 0.9v 1279.45n 0.9v 1279.55n 0.9v 1289.45n 0.9v 1289.55n 0.0v 1299.45n 0.0v 1299.55n 0.9v 1309.45n 0.9v 1309.55n 0.0v 1319.45n 0.0v 1319.55n 0.0v 1329.45n 0.0v 1329.55n 0.0v 1339.45n 0.0v 1339.55n 0.0v 1349.45n 0.0v 1349.55n 0.0v 1359.45n 0.0v 1359.55n 0.0v 1369.45n 0.0v 1369.55n 0.0v 1379.45n 0.0v 1379.55n 0.0v 1389.45n 0.0v 1389.55n 0.0v 1399.45n 0.0v 1399.55n 0.0v 1409.45n 0.0v 1409.55n 0.0v 1419.45n 0.0v 1419.55n 0.0v 1429.45n 0.0v 1429.55n 0.0v 1439.45n 0.0v 1439.55n 0.0v 1449.45n 0.0v 1449.55n 0.0v 1459.45n 0.0v 1459.55n 0.9v 1469.45n 0.9v 1469.55n 0.9v 1479.45n 0.9v 1479.55n 0.9v 1489.45n 0.9v 1489.55n 0.9v 1499.45n 0.9v 1499.55n 0.9v 1509.45n 0.9v 1509.55n 0.9v 1519.45n 0.9v 1519.55n 0.9v 1529.45n 0.9v 1529.55n 0.9v 1539.45n 0.9v 1539.55n 0.9v 1549.45n 0.9v 1549.55n 0.9v 1559.45n 0.9v 1559.55n 0.9v 1569.45n 0.9v 1569.55n 0.9v 1579.45n 0.9v 1579.55n 0.9v 1589.45n 0.9v 1589.55n 0.9v 1599.45n 0.9v 1599.55n 0.9v 1609.45n 0.9v 1609.55n 0.9v 1619.45n 0.9v 1619.55n 0.9v 1629.45n 0.9v 1629.55n 0.9v 1639.45n 0.9v 1639.55n 0.9v 1649.45n 0.9v 1649.55n 0.9v 1659.45n 0.9v 1659.55n 0.9v 1669.45n 0.9v 1669.55n 0.9v 1679.45n 0.9v 1679.55n 0.9v 1689.45n 0.9v 1689.55n 0.9v 1699.45n 0.9v 1699.55n 0.9v 1709.45n 0.9v 1709.55n 0.9v 1719.45n 0.9v 1719.55n 0.9v 1729.45n 0.9v 1729.55n 0.9v 1739.45n 0.9v 1739.55n 0.9v 1749.45n 0.9v 1749.55n 0.9v 1759.45n 0.9v 1759.55n 0.9v 1769.45n 0.9v 1769.55n 0.9v 1779.45n 0.9v 1779.55n 0.9v 1789.45n 0.9v 1789.55n 0.9v 1799.45n 0.9v 1799.55n 0.9v 1809.45n 0.9v 1809.55n 0.9v 1819.45n 0.9v 1819.55n 0.9v 1829.45n 0.9v 1829.55n 0.9v 1839.45n 0.9v 1839.55n 0.9v 1849.45n 0.9v 1849.55n 0.9v 1859.45n 0.9v 1859.55n 0.9v 1869.45n 0.9v 1869.55n 0.9v 1879.45n 0.9v 1879.55n 0.9v 1889.45n 0.9v 1889.55n 0.9v 1899.45n 0.9v 1899.55n 0.9v 1909.45n 0.9v 1909.55n 0.0v 1919.45n 0.0v 1919.55n 0.0v 1929.45n 0.0v 1929.55n 0.0v 1939.45n 0.0v 1939.55n 0.9v 1949.45n 0.9v 1949.55n 0.9v 1959.45n 0.9v 1959.55n 0.9v 1969.45n 0.9v 1969.55n 0.9v 1979.45n 0.9v 1979.55n 0.9v 1989.45n 0.9v 1989.55n 0.9v 1999.45n 0.9v 1999.55n 0.9v 2009.45n 0.9v 2009.55n 0.9v 2019.45n 0.9v 2019.55n 0.9v 2029.45n 0.9v 2029.55n 0.9v 2039.45n 0.9v 2039.55n 0.9v 2049.45n 0.9v 2049.55n 0.9v )
* (time, data): [(0, 0), (10, 0), (20, 1), (30, 1), (40, 1), (50, 1), (60, 0), (70, 0), (80, 1), (90, 1), (100, 1), (110, 1), (120, 1), (130, 1), (140, 1), (150, 0), (160, 0), (170, 0), (180, 0), (190, 0), (200, 0), (210, 0), (220, 0), (230, 0), (240, 0), (250, 0), (260, 0), (270, 0), (280, 0), (290, 0), (300, 0), (310, 0), (320, 0), (330, 0), (340, 0), (350, 0), (360, 0), (370, 0), (380, 0), (390, 0), (400, 0), (410, 0), (420, 0), (430, 0), (440, 0), (450, 1), (460, 1), (470, 1), (480, 1), (490, 1), (500, 0), (510, 0), (520, 0), (530, 0), (540, 1), (550, 1), (560, 1), (570, 1), (580, 1), (590, 1), (600, 1), (610, 1), (620, 1), (630, 1), (640, 1), (650, 1), (660, 0), (670, 0), (680, 0), (690, 0), (700, 1), (710, 0), (720, 0), (730, 0), (740, 0), (750, 0), (760, 0), (770, 0), (780, 0), (790, 0), (800, 0), (810, 1), (820, 1), (830, 1), (840, 1), (850, 1), (860, 0), (870, 0), (880, 0), (890, 0), (900, 0), (910, 1), (920, 1), (930, 1), (940, 1), (950, 1), (960, 1), (970, 1), (980, 1), (990, 0), (1000, 0), (1010, 1), (1020, 1), (1030, 1), (1040, 1), (1050, 1), (1060, 1), (1070, 1), (1080, 1), (1090, 1), (1100, 1), (1110, 1), (1120, 1), (1130, 1), (1140, 1), (1150, 1), (1160, 1), (1170, 1), (1180, 1), (1190, 1), (1200, 1), (1210, 1), (1220, 1), (1230, 0), (1240, 1), (1250, 0), (1260, 0), (1270, 0), (1280, 0), (1290, 0), (1300, 0), (1310, 1), (1320, 1), (1330, 1), (1340, 1), (1350, 0), (1360, 0), (1370, 1), (1380, 1), (1390, 1), (1400, 1), (1410, 1), (1420, 1), (1430, 1), (1440, 1), (1450, 1), (1460, 0), (1470, 0), (1480, 0), (1490, 0), (1500, 0), (1510, 0), (1520, 0), (1530, 0), (1540, 0), (1550, 1), (1560, 1), (1570, 1), (1580, 1), (1590, 1), (1600, 1), (1610, 1), (1620, 1), (1630, 1), (1640, 1), (1650, 1), (1660, 1), (1670, 1), (1680, 1), (1690, 1), (1700, 1), (1710, 1), (1720, 1), (1730, 1), (1740, 1), (1750, 1), (1760, 1), (1770, 0), (1780, 0), (1790, 0), (1800, 0), (1810, 0), (1820, 0), (1830, 0), (1840, 0), (1850, 1), (1860, 1), (1870, 1), (1880, 1), (1890, 0), (1900, 0), (1910, 1), (1920, 1), (1930, 1), (1940, 0), (1950, 0), (1960, 0), (1970, 0), (1980, 0), (1990, 0), (2000, 0), (2010, 0), (2020, 0), (2030, 0), (2040, 0), (2050, 0)]
Vdin0_2  din0_2  0 PWL (0n 0.0v 9.45n 0.0v 9.55n 0.0v 19.45n 0.0v 19.55n 0.9v 29.45n 0.9v 29.55n 0.9v 39.45n 0.9v 39.55n 0.9v 49.45n 0.9v 49.55n 0.9v 59.45n 0.9v 59.55n 0.0v 69.45n 0.0v 69.55n 0.0v 79.45n 0.0v 79.55n 0.9v 89.45n 0.9v 89.55n 0.9v 99.45n 0.9v 99.55n 0.9v 109.45n 0.9v 109.55n 0.9v 119.45n 0.9v 119.55n 0.9v 129.45n 0.9v 129.55n 0.9v 139.45n 0.9v 139.55n 0.9v 149.45n 0.9v 149.55n 0.0v 159.45n 0.0v 159.55n 0.0v 169.45n 0.0v 169.55n 0.0v 179.45n 0.0v 179.55n 0.0v 189.45n 0.0v 189.55n 0.0v 199.45n 0.0v 199.55n 0.0v 209.45n 0.0v 209.55n 0.0v 219.45n 0.0v 219.55n 0.0v 229.45n 0.0v 229.55n 0.0v 239.45n 0.0v 239.55n 0.0v 249.45n 0.0v 249.55n 0.0v 259.45n 0.0v 259.55n 0.0v 269.45n 0.0v 269.55n 0.0v 279.45n 0.0v 279.55n 0.0v 289.45n 0.0v 289.55n 0.0v 299.45n 0.0v 299.55n 0.0v 309.45n 0.0v 309.55n 0.0v 319.45n 0.0v 319.55n 0.0v 329.45n 0.0v 329.55n 0.0v 339.45n 0.0v 339.55n 0.0v 349.45n 0.0v 349.55n 0.0v 359.45n 0.0v 359.55n 0.0v 369.45n 0.0v 369.55n 0.0v 379.45n 0.0v 379.55n 0.0v 389.45n 0.0v 389.55n 0.0v 399.45n 0.0v 399.55n 0.0v 409.45n 0.0v 409.55n 0.0v 419.45n 0.0v 419.55n 0.0v 429.45n 0.0v 429.55n 0.0v 439.45n 0.0v 439.55n 0.0v 449.45n 0.0v 449.55n 0.9v 459.45n 0.9v 459.55n 0.9v 469.45n 0.9v 469.55n 0.9v 479.45n 0.9v 479.55n 0.9v 489.45n 0.9v 489.55n 0.9v 499.45n 0.9v 499.55n 0.0v 509.45n 0.0v 509.55n 0.0v 519.45n 0.0v 519.55n 0.0v 529.45n 0.0v 529.55n 0.0v 539.45n 0.0v 539.55n 0.9v 549.45n 0.9v 549.55n 0.9v 559.45n 0.9v 559.55n 0.9v 569.45n 0.9v 569.55n 0.9v 579.45n 0.9v 579.55n 0.9v 589.45n 0.9v 589.55n 0.9v 599.45n 0.9v 599.55n 0.9v 609.45n 0.9v 609.55n 0.9v 619.45n 0.9v 619.55n 0.9v 629.45n 0.9v 629.55n 0.9v 639.45n 0.9v 639.55n 0.9v 649.45n 0.9v 649.55n 0.9v 659.45n 0.9v 659.55n 0.0v 669.45n 0.0v 669.55n 0.0v 679.45n 0.0v 679.55n 0.0v 689.45n 0.0v 689.55n 0.0v 699.45n 0.0v 699.55n 0.9v 709.45n 0.9v 709.55n 0.0v 719.45n 0.0v 719.55n 0.0v 729.45n 0.0v 729.55n 0.0v 739.45n 0.0v 739.55n 0.0v 749.45n 0.0v 749.55n 0.0v 759.45n 0.0v 759.55n 0.0v 769.45n 0.0v 769.55n 0.0v 779.45n 0.0v 779.55n 0.0v 789.45n 0.0v 789.55n 0.0v 799.45n 0.0v 799.55n 0.0v 809.45n 0.0v 809.55n 0.9v 819.45n 0.9v 819.55n 0.9v 829.45n 0.9v 829.55n 0.9v 839.45n 0.9v 839.55n 0.9v 849.45n 0.9v 849.55n 0.9v 859.45n 0.9v 859.55n 0.0v 869.45n 0.0v 869.55n 0.0v 879.45n 0.0v 879.55n 0.0v 889.45n 0.0v 889.55n 0.0v 899.45n 0.0v 899.55n 0.0v 909.45n 0.0v 909.55n 0.9v 919.45n 0.9v 919.55n 0.9v 929.45n 0.9v 929.55n 0.9v 939.45n 0.9v 939.55n 0.9v 949.45n 0.9v 949.55n 0.9v 959.45n 0.9v 959.55n 0.9v 969.45n 0.9v 969.55n 0.9v 979.45n 0.9v 979.55n 0.9v 989.45n 0.9v 989.55n 0.0v 999.45n 0.0v 999.55n 0.0v 1009.45n 0.0v 1009.55n 0.9v 1019.45n 0.9v 1019.55n 0.9v 1029.45n 0.9v 1029.55n 0.9v 1039.45n 0.9v 1039.55n 0.9v 1049.45n 0.9v 1049.55n 0.9v 1059.45n 0.9v 1059.55n 0.9v 1069.45n 0.9v 1069.55n 0.9v 1079.45n 0.9v 1079.55n 0.9v 1089.45n 0.9v 1089.55n 0.9v 1099.45n 0.9v 1099.55n 0.9v 1109.45n 0.9v 1109.55n 0.9v 1119.45n 0.9v 1119.55n 0.9v 1129.45n 0.9v 1129.55n 0.9v 1139.45n 0.9v 1139.55n 0.9v 1149.45n 0.9v 1149.55n 0.9v 1159.45n 0.9v 1159.55n 0.9v 1169.45n 0.9v 1169.55n 0.9v 1179.45n 0.9v 1179.55n 0.9v 1189.45n 0.9v 1189.55n 0.9v 1199.45n 0.9v 1199.55n 0.9v 1209.45n 0.9v 1209.55n 0.9v 1219.45n 0.9v 1219.55n 0.9v 1229.45n 0.9v 1229.55n 0.0v 1239.45n 0.0v 1239.55n 0.9v 1249.45n 0.9v 1249.55n 0.0v 1259.45n 0.0v 1259.55n 0.0v 1269.45n 0.0v 1269.55n 0.0v 1279.45n 0.0v 1279.55n 0.0v 1289.45n 0.0v 1289.55n 0.0v 1299.45n 0.0v 1299.55n 0.0v 1309.45n 0.0v 1309.55n 0.9v 1319.45n 0.9v 1319.55n 0.9v 1329.45n 0.9v 1329.55n 0.9v 1339.45n 0.9v 1339.55n 0.9v 1349.45n 0.9v 1349.55n 0.0v 1359.45n 0.0v 1359.55n 0.0v 1369.45n 0.0v 1369.55n 0.9v 1379.45n 0.9v 1379.55n 0.9v 1389.45n 0.9v 1389.55n 0.9v 1399.45n 0.9v 1399.55n 0.9v 1409.45n 0.9v 1409.55n 0.9v 1419.45n 0.9v 1419.55n 0.9v 1429.45n 0.9v 1429.55n 0.9v 1439.45n 0.9v 1439.55n 0.9v 1449.45n 0.9v 1449.55n 0.9v 1459.45n 0.9v 1459.55n 0.0v 1469.45n 0.0v 1469.55n 0.0v 1479.45n 0.0v 1479.55n 0.0v 1489.45n 0.0v 1489.55n 0.0v 1499.45n 0.0v 1499.55n 0.0v 1509.45n 0.0v 1509.55n 0.0v 1519.45n 0.0v 1519.55n 0.0v 1529.45n 0.0v 1529.55n 0.0v 1539.45n 0.0v 1539.55n 0.0v 1549.45n 0.0v 1549.55n 0.9v 1559.45n 0.9v 1559.55n 0.9v 1569.45n 0.9v 1569.55n 0.9v 1579.45n 0.9v 1579.55n 0.9v 1589.45n 0.9v 1589.55n 0.9v 1599.45n 0.9v 1599.55n 0.9v 1609.45n 0.9v 1609.55n 0.9v 1619.45n 0.9v 1619.55n 0.9v 1629.45n 0.9v 1629.55n 0.9v 1639.45n 0.9v 1639.55n 0.9v 1649.45n 0.9v 1649.55n 0.9v 1659.45n 0.9v 1659.55n 0.9v 1669.45n 0.9v 1669.55n 0.9v 1679.45n 0.9v 1679.55n 0.9v 1689.45n 0.9v 1689.55n 0.9v 1699.45n 0.9v 1699.55n 0.9v 1709.45n 0.9v 1709.55n 0.9v 1719.45n 0.9v 1719.55n 0.9v 1729.45n 0.9v 1729.55n 0.9v 1739.45n 0.9v 1739.55n 0.9v 1749.45n 0.9v 1749.55n 0.9v 1759.45n 0.9v 1759.55n 0.9v 1769.45n 0.9v 1769.55n 0.0v 1779.45n 0.0v 1779.55n 0.0v 1789.45n 0.0v 1789.55n 0.0v 1799.45n 0.0v 1799.55n 0.0v 1809.45n 0.0v 1809.55n 0.0v 1819.45n 0.0v 1819.55n 0.0v 1829.45n 0.0v 1829.55n 0.0v 1839.45n 0.0v 1839.55n 0.0v 1849.45n 0.0v 1849.55n 0.9v 1859.45n 0.9v 1859.55n 0.9v 1869.45n 0.9v 1869.55n 0.9v 1879.45n 0.9v 1879.55n 0.9v 1889.45n 0.9v 1889.55n 0.0v 1899.45n 0.0v 1899.55n 0.0v 1909.45n 0.0v 1909.55n 0.9v 1919.45n 0.9v 1919.55n 0.9v 1929.45n 0.9v 1929.55n 0.9v 1939.45n 0.9v 1939.55n 0.0v 1949.45n 0.0v 1949.55n 0.0v 1959.45n 0.0v 1959.55n 0.0v 1969.45n 0.0v 1969.55n 0.0v 1979.45n 0.0v 1979.55n 0.0v 1989.45n 0.0v 1989.55n 0.0v 1999.45n 0.0v 1999.55n 0.0v 2009.45n 0.0v 2009.55n 0.0v 2019.45n 0.0v 2019.55n 0.0v 2029.45n 0.0v 2029.55n 0.0v 2039.45n 0.0v 2039.55n 0.0v 2049.45n 0.0v 2049.55n 0.0v )
* (time, data): [(0, 0), (10, 1), (20, 1), (30, 0), (40, 0), (50, 0), (60, 0), (70, 1), (80, 1), (90, 0), (100, 0), (110, 0), (120, 0), (130, 0), (140, 1), (150, 1), (160, 0), (170, 0), (180, 0), (190, 0), (200, 0), (210, 0), (220, 0), (230, 0), (240, 0), (250, 0), (260, 0), (270, 0), (280, 0), (290, 0), (300, 0), (310, 0), (320, 0), (330, 0), (340, 0), (350, 0), (360, 0), (370, 0), (380, 0), (390, 0), (400, 0), (410, 0), (420, 0), (430, 0), (440, 0), (450, 0), (460, 0), (470, 0), (480, 0), (490, 1), (500, 1), (510, 1), (520, 1), (530, 1), (540, 0), (550, 0), (560, 0), (570, 0), (580, 0), (590, 0), (600, 0), (610, 0), (620, 0), (630, 0), (640, 0), (650, 0), (660, 0), (670, 0), (680, 0), (690, 0), (700, 1), (710, 1), (720, 1), (730, 1), (740, 1), (750, 1), (760, 1), (770, 1), (780, 1), (790, 1), (800, 0), (810, 1), (820, 1), (830, 1), (840, 1), (850, 1), (860, 0), (870, 0), (880, 0), (890, 1), (900, 1), (910, 1), (920, 1), (930, 1), (940, 0), (950, 0), (960, 0), (970, 0), (980, 0), (990, 1), (1000, 1), (1010, 1), (1020, 1), (1030, 1), (1040, 1), (1050, 1), (1060, 1), (1070, 1), (1080, 1), (1090, 1), (1100, 1), (1110, 1), (1120, 1), (1130, 1), (1140, 1), (1150, 1), (1160, 1), (1170, 1), (1180, 1), (1190, 1), (1200, 1), (1210, 1), (1220, 1), (1230, 0), (1240, 1), (1250, 1), (1260, 1), (1270, 1), (1280, 1), (1290, 1), (1300, 1), (1310, 1), (1320, 1), (1330, 0), (1340, 0), (1350, 0), (1360, 0), (1370, 0), (1380, 0), (1390, 0), (1400, 0), (1410, 0), (1420, 0), (1430, 0), (1440, 0), (1450, 0), (1460, 1), (1470, 1), (1480, 1), (1490, 1), (1500, 1), (1510, 1), (1520, 1), (1530, 1), (1540, 1), (1550, 0), (1560, 0), (1570, 0), (1580, 0), (1590, 0), (1600, 0), (1610, 0), (1620, 1), (1630, 1), (1640, 1), (1650, 1), (1660, 1), (1670, 1), (1680, 1), (1690, 1), (1700, 1), (1710, 1), (1720, 1), (1730, 1), (1740, 1), (1750, 1), (1760, 1), (1770, 0), (1780, 0), (1790, 0), (1800, 0), (1810, 0), (1820, 0), (1830, 0), (1840, 0), (1850, 0), (1860, 0), (1870, 0), (1880, 0), (1890, 0), (1900, 0), (1910, 0), (1920, 0), (1930, 0), (1940, 0), (1950, 0), (1960, 0), (1970, 0), (1980, 0), (1990, 0), (2000, 0), (2010, 0), (2020, 0), (2030, 0), (2040, 0), (2050, 0)]
Vdin0_3  din0_3  0 PWL (0n 0.0v 9.45n 0.0v 9.55n 0.9v 19.45n 0.9v 19.55n 0.9v 29.45n 0.9v 29.55n 0.0v 39.45n 0.0v 39.55n 0.0v 49.45n 0.0v 49.55n 0.0v 59.45n 0.0v 59.55n 0.0v 69.45n 0.0v 69.55n 0.9v 79.45n 0.9v 79.55n 0.9v 89.45n 0.9v 89.55n 0.0v 99.45n 0.0v 99.55n 0.0v 109.45n 0.0v 109.55n 0.0v 119.45n 0.0v 119.55n 0.0v 129.45n 0.0v 129.55n 0.0v 139.45n 0.0v 139.55n 0.9v 149.45n 0.9v 149.55n 0.9v 159.45n 0.9v 159.55n 0.0v 169.45n 0.0v 169.55n 0.0v 179.45n 0.0v 179.55n 0.0v 189.45n 0.0v 189.55n 0.0v 199.45n 0.0v 199.55n 0.0v 209.45n 0.0v 209.55n 0.0v 219.45n 0.0v 219.55n 0.0v 229.45n 0.0v 229.55n 0.0v 239.45n 0.0v 239.55n 0.0v 249.45n 0.0v 249.55n 0.0v 259.45n 0.0v 259.55n 0.0v 269.45n 0.0v 269.55n 0.0v 279.45n 0.0v 279.55n 0.0v 289.45n 0.0v 289.55n 0.0v 299.45n 0.0v 299.55n 0.0v 309.45n 0.0v 309.55n 0.0v 319.45n 0.0v 319.55n 0.0v 329.45n 0.0v 329.55n 0.0v 339.45n 0.0v 339.55n 0.0v 349.45n 0.0v 349.55n 0.0v 359.45n 0.0v 359.55n 0.0v 369.45n 0.0v 369.55n 0.0v 379.45n 0.0v 379.55n 0.0v 389.45n 0.0v 389.55n 0.0v 399.45n 0.0v 399.55n 0.0v 409.45n 0.0v 409.55n 0.0v 419.45n 0.0v 419.55n 0.0v 429.45n 0.0v 429.55n 0.0v 439.45n 0.0v 439.55n 0.0v 449.45n 0.0v 449.55n 0.0v 459.45n 0.0v 459.55n 0.0v 469.45n 0.0v 469.55n 0.0v 479.45n 0.0v 479.55n 0.0v 489.45n 0.0v 489.55n 0.9v 499.45n 0.9v 499.55n 0.9v 509.45n 0.9v 509.55n 0.9v 519.45n 0.9v 519.55n 0.9v 529.45n 0.9v 529.55n 0.9v 539.45n 0.9v 539.55n 0.0v 549.45n 0.0v 549.55n 0.0v 559.45n 0.0v 559.55n 0.0v 569.45n 0.0v 569.55n 0.0v 579.45n 0.0v 579.55n 0.0v 589.45n 0.0v 589.55n 0.0v 599.45n 0.0v 599.55n 0.0v 609.45n 0.0v 609.55n 0.0v 619.45n 0.0v 619.55n 0.0v 629.45n 0.0v 629.55n 0.0v 639.45n 0.0v 639.55n 0.0v 649.45n 0.0v 649.55n 0.0v 659.45n 0.0v 659.55n 0.0v 669.45n 0.0v 669.55n 0.0v 679.45n 0.0v 679.55n 0.0v 689.45n 0.0v 689.55n 0.0v 699.45n 0.0v 699.55n 0.9v 709.45n 0.9v 709.55n 0.9v 719.45n 0.9v 719.55n 0.9v 729.45n 0.9v 729.55n 0.9v 739.45n 0.9v 739.55n 0.9v 749.45n 0.9v 749.55n 0.9v 759.45n 0.9v 759.55n 0.9v 769.45n 0.9v 769.55n 0.9v 779.45n 0.9v 779.55n 0.9v 789.45n 0.9v 789.55n 0.9v 799.45n 0.9v 799.55n 0.0v 809.45n 0.0v 809.55n 0.9v 819.45n 0.9v 819.55n 0.9v 829.45n 0.9v 829.55n 0.9v 839.45n 0.9v 839.55n 0.9v 849.45n 0.9v 849.55n 0.9v 859.45n 0.9v 859.55n 0.0v 869.45n 0.0v 869.55n 0.0v 879.45n 0.0v 879.55n 0.0v 889.45n 0.0v 889.55n 0.9v 899.45n 0.9v 899.55n 0.9v 909.45n 0.9v 909.55n 0.9v 919.45n 0.9v 919.55n 0.9v 929.45n 0.9v 929.55n 0.9v 939.45n 0.9v 939.55n 0.0v 949.45n 0.0v 949.55n 0.0v 959.45n 0.0v 959.55n 0.0v 969.45n 0.0v 969.55n 0.0v 979.45n 0.0v 979.55n 0.0v 989.45n 0.0v 989.55n 0.9v 999.45n 0.9v 999.55n 0.9v 1009.45n 0.9v 1009.55n 0.9v 1019.45n 0.9v 1019.55n 0.9v 1029.45n 0.9v 1029.55n 0.9v 1039.45n 0.9v 1039.55n 0.9v 1049.45n 0.9v 1049.55n 0.9v 1059.45n 0.9v 1059.55n 0.9v 1069.45n 0.9v 1069.55n 0.9v 1079.45n 0.9v 1079.55n 0.9v 1089.45n 0.9v 1089.55n 0.9v 1099.45n 0.9v 1099.55n 0.9v 1109.45n 0.9v 1109.55n 0.9v 1119.45n 0.9v 1119.55n 0.9v 1129.45n 0.9v 1129.55n 0.9v 1139.45n 0.9v 1139.55n 0.9v 1149.45n 0.9v 1149.55n 0.9v 1159.45n 0.9v 1159.55n 0.9v 1169.45n 0.9v 1169.55n 0.9v 1179.45n 0.9v 1179.55n 0.9v 1189.45n 0.9v 1189.55n 0.9v 1199.45n 0.9v 1199.55n 0.9v 1209.45n 0.9v 1209.55n 0.9v 1219.45n 0.9v 1219.55n 0.9v 1229.45n 0.9v 1229.55n 0.0v 1239.45n 0.0v 1239.55n 0.9v 1249.45n 0.9v 1249.55n 0.9v 1259.45n 0.9v 1259.55n 0.9v 1269.45n 0.9v 1269.55n 0.9v 1279.45n 0.9v 1279.55n 0.9v 1289.45n 0.9v 1289.55n 0.9v 1299.45n 0.9v 1299.55n 0.9v 1309.45n 0.9v 1309.55n 0.9v 1319.45n 0.9v 1319.55n 0.9v 1329.45n 0.9v 1329.55n 0.0v 1339.45n 0.0v 1339.55n 0.0v 1349.45n 0.0v 1349.55n 0.0v 1359.45n 0.0v 1359.55n 0.0v 1369.45n 0.0v 1369.55n 0.0v 1379.45n 0.0v 1379.55n 0.0v 1389.45n 0.0v 1389.55n 0.0v 1399.45n 0.0v 1399.55n 0.0v 1409.45n 0.0v 1409.55n 0.0v 1419.45n 0.0v 1419.55n 0.0v 1429.45n 0.0v 1429.55n 0.0v 1439.45n 0.0v 1439.55n 0.0v 1449.45n 0.0v 1449.55n 0.0v 1459.45n 0.0v 1459.55n 0.9v 1469.45n 0.9v 1469.55n 0.9v 1479.45n 0.9v 1479.55n 0.9v 1489.45n 0.9v 1489.55n 0.9v 1499.45n 0.9v 1499.55n 0.9v 1509.45n 0.9v 1509.55n 0.9v 1519.45n 0.9v 1519.55n 0.9v 1529.45n 0.9v 1529.55n 0.9v 1539.45n 0.9v 1539.55n 0.9v 1549.45n 0.9v 1549.55n 0.0v 1559.45n 0.0v 1559.55n 0.0v 1569.45n 0.0v 1569.55n 0.0v 1579.45n 0.0v 1579.55n 0.0v 1589.45n 0.0v 1589.55n 0.0v 1599.45n 0.0v 1599.55n 0.0v 1609.45n 0.0v 1609.55n 0.0v 1619.45n 0.0v 1619.55n 0.9v 1629.45n 0.9v 1629.55n 0.9v 1639.45n 0.9v 1639.55n 0.9v 1649.45n 0.9v 1649.55n 0.9v 1659.45n 0.9v 1659.55n 0.9v 1669.45n 0.9v 1669.55n 0.9v 1679.45n 0.9v 1679.55n 0.9v 1689.45n 0.9v 1689.55n 0.9v 1699.45n 0.9v 1699.55n 0.9v 1709.45n 0.9v 1709.55n 0.9v 1719.45n 0.9v 1719.55n 0.9v 1729.45n 0.9v 1729.55n 0.9v 1739.45n 0.9v 1739.55n 0.9v 1749.45n 0.9v 1749.55n 0.9v 1759.45n 0.9v 1759.55n 0.9v 1769.45n 0.9v 1769.55n 0.0v 1779.45n 0.0v 1779.55n 0.0v 1789.45n 0.0v 1789.55n 0.0v 1799.45n 0.0v 1799.55n 0.0v 1809.45n 0.0v 1809.55n 0.0v 1819.45n 0.0v 1819.55n 0.0v 1829.45n 0.0v 1829.55n 0.0v 1839.45n 0.0v 1839.55n 0.0v 1849.45n 0.0v 1849.55n 0.0v 1859.45n 0.0v 1859.55n 0.0v 1869.45n 0.0v 1869.55n 0.0v 1879.45n 0.0v 1879.55n 0.0v 1889.45n 0.0v 1889.55n 0.0v 1899.45n 0.0v 1899.55n 0.0v 1909.45n 0.0v 1909.55n 0.0v 1919.45n 0.0v 1919.55n 0.0v 1929.45n 0.0v 1929.55n 0.0v 1939.45n 0.0v 1939.55n 0.0v 1949.45n 0.0v 1949.55n 0.0v 1959.45n 0.0v 1959.55n 0.0v 1969.45n 0.0v 1969.55n 0.0v 1979.45n 0.0v 1979.55n 0.0v 1989.45n 0.0v 1989.55n 0.0v 1999.45n 0.0v 1999.55n 0.0v 2009.45n 0.0v 2009.55n 0.0v 2019.45n 0.0v 2019.55n 0.0v 2029.45n 0.0v 2029.55n 0.0v 2039.45n 0.0v 2039.55n 0.0v 2049.45n 0.0v 2049.55n 0.0v )
* (time, data): [(0, 0), (10, 1), (20, 1), (30, 0), (40, 0), (50, 0), (60, 1), (70, 0), (80, 0), (90, 1), (100, 1), (110, 1), (120, 1), (130, 1), (140, 0), (150, 1), (160, 1), (170, 1), (180, 1), (190, 1), (200, 1), (210, 1), (220, 0), (230, 0), (240, 0), (250, 0), (260, 0), (270, 0), (280, 0), (290, 0), (300, 0), (310, 0), (320, 0), (330, 0), (340, 0), (350, 0), (360, 0), (370, 0), (380, 0), (390, 0), (400, 0), (410, 0), (420, 1), (430, 1), (440, 1), (450, 1), (460, 1), (470, 1), (480, 1), (490, 0), (500, 1), (510, 1), (520, 1), (530, 1), (540, 1), (550, 1), (560, 1), (570, 1), (580, 1), (590, 1), (600, 1), (610, 0), (620, 0), (630, 0), (640, 1), (650, 1), (660, 0), (670, 0), (680, 0), (690, 0), (700, 0), (710, 1), (720, 1), (730, 1), (740, 1), (750, 1), (760, 1), (770, 1), (780, 1), (790, 1), (800, 0), (810, 1), (820, 1), (830, 1), (840, 1), (850, 1), (860, 1), (870, 1), (880, 1), (890, 1), (900, 1), (910, 1), (920, 1), (930, 1), (940, 1), (950, 1), (960, 1), (970, 1), (980, 1), (990, 1), (1000, 0), (1010, 0), (1020, 0), (1030, 0), (1040, 0), (1050, 0), (1060, 0), (1070, 0), (1080, 0), (1090, 0), (1100, 0), (1110, 0), (1120, 0), (1130, 0), (1140, 0), (1150, 0), (1160, 0), (1170, 0), (1180, 0), (1190, 0), (1200, 0), (1210, 0), (1220, 0), (1230, 1), (1240, 0), (1250, 0), (1260, 0), (1270, 0), (1280, 0), (1290, 1), (1300, 1), (1310, 1), (1320, 1), (1330, 0), (1340, 0), (1350, 1), (1360, 1), (1370, 0), (1380, 0), (1390, 0), (1400, 0), (1410, 0), (1420, 0), (1430, 0), (1440, 0), (1450, 0), (1460, 1), (1470, 0), (1480, 0), (1490, 0), (1500, 0), (1510, 0), (1520, 0), (1530, 0), (1540, 0), (1550, 0), (1560, 0), (1570, 0), (1580, 0), (1590, 0), (1600, 0), (1610, 0), (1620, 1), (1630, 1), (1640, 1), (1650, 1), (1660, 1), (1670, 1), (1680, 1), (1690, 1), (1700, 1), (1710, 1), (1720, 1), (1730, 1), (1740, 1), (1750, 1), (1760, 1), (1770, 1), (1780, 1), (1790, 1), (1800, 1), (1810, 1), (1820, 1), (1830, 1), (1840, 1), (1850, 0), (1860, 0), (1870, 0), (1880, 0), (1890, 1), (1900, 1), (1910, 0), (1920, 0), (1930, 0), (1940, 0), (1950, 0), (1960, 0), (1970, 0), (1980, 0), (1990, 0), (2000, 0), (2010, 0), (2020, 0), (2030, 0), (2040, 0), (2050, 0)]
Vdin0_4  din0_4  0 PWL (0n 0.0v 9.45n 0.0v 9.55n 0.9v 19.45n 0.9v 19.55n 0.9v 29.45n 0.9v 29.55n 0.0v 39.45n 0.0v 39.55n 0.0v 49.45n 0.0v 49.55n 0.0v 59.45n 0.0v 59.55n 0.9v 69.45n 0.9v 69.55n 0.0v 79.45n 0.0v 79.55n 0.0v 89.45n 0.0v 89.55n 0.9v 99.45n 0.9v 99.55n 0.9v 109.45n 0.9v 109.55n 0.9v 119.45n 0.9v 119.55n 0.9v 129.45n 0.9v 129.55n 0.9v 139.45n 0.9v 139.55n 0.0v 149.45n 0.0v 149.55n 0.9v 159.45n 0.9v 159.55n 0.9v 169.45n 0.9v 169.55n 0.9v 179.45n 0.9v 179.55n 0.9v 189.45n 0.9v 189.55n 0.9v 199.45n 0.9v 199.55n 0.9v 209.45n 0.9v 209.55n 0.9v 219.45n 0.9v 219.55n 0.0v 229.45n 0.0v 229.55n 0.0v 239.45n 0.0v 239.55n 0.0v 249.45n 0.0v 249.55n 0.0v 259.45n 0.0v 259.55n 0.0v 269.45n 0.0v 269.55n 0.0v 279.45n 0.0v 279.55n 0.0v 289.45n 0.0v 289.55n 0.0v 299.45n 0.0v 299.55n 0.0v 309.45n 0.0v 309.55n 0.0v 319.45n 0.0v 319.55n 0.0v 329.45n 0.0v 329.55n 0.0v 339.45n 0.0v 339.55n 0.0v 349.45n 0.0v 349.55n 0.0v 359.45n 0.0v 359.55n 0.0v 369.45n 0.0v 369.55n 0.0v 379.45n 0.0v 379.55n 0.0v 389.45n 0.0v 389.55n 0.0v 399.45n 0.0v 399.55n 0.0v 409.45n 0.0v 409.55n 0.0v 419.45n 0.0v 419.55n 0.9v 429.45n 0.9v 429.55n 0.9v 439.45n 0.9v 439.55n 0.9v 449.45n 0.9v 449.55n 0.9v 459.45n 0.9v 459.55n 0.9v 469.45n 0.9v 469.55n 0.9v 479.45n 0.9v 479.55n 0.9v 489.45n 0.9v 489.55n 0.0v 499.45n 0.0v 499.55n 0.9v 509.45n 0.9v 509.55n 0.9v 519.45n 0.9v 519.55n 0.9v 529.45n 0.9v 529.55n 0.9v 539.45n 0.9v 539.55n 0.9v 549.45n 0.9v 549.55n 0.9v 559.45n 0.9v 559.55n 0.9v 569.45n 0.9v 569.55n 0.9v 579.45n 0.9v 579.55n 0.9v 589.45n 0.9v 589.55n 0.9v 599.45n 0.9v 599.55n 0.9v 609.45n 0.9v 609.55n 0.0v 619.45n 0.0v 619.55n 0.0v 629.45n 0.0v 629.55n 0.0v 639.45n 0.0v 639.55n 0.9v 649.45n 0.9v 649.55n 0.9v 659.45n 0.9v 659.55n 0.0v 669.45n 0.0v 669.55n 0.0v 679.45n 0.0v 679.55n 0.0v 689.45n 0.0v 689.55n 0.0v 699.45n 0.0v 699.55n 0.0v 709.45n 0.0v 709.55n 0.9v 719.45n 0.9v 719.55n 0.9v 729.45n 0.9v 729.55n 0.9v 739.45n 0.9v 739.55n 0.9v 749.45n 0.9v 749.55n 0.9v 759.45n 0.9v 759.55n 0.9v 769.45n 0.9v 769.55n 0.9v 779.45n 0.9v 779.55n 0.9v 789.45n 0.9v 789.55n 0.9v 799.45n 0.9v 799.55n 0.0v 809.45n 0.0v 809.55n 0.9v 819.45n 0.9v 819.55n 0.9v 829.45n 0.9v 829.55n 0.9v 839.45n 0.9v 839.55n 0.9v 849.45n 0.9v 849.55n 0.9v 859.45n 0.9v 859.55n 0.9v 869.45n 0.9v 869.55n 0.9v 879.45n 0.9v 879.55n 0.9v 889.45n 0.9v 889.55n 0.9v 899.45n 0.9v 899.55n 0.9v 909.45n 0.9v 909.55n 0.9v 919.45n 0.9v 919.55n 0.9v 929.45n 0.9v 929.55n 0.9v 939.45n 0.9v 939.55n 0.9v 949.45n 0.9v 949.55n 0.9v 959.45n 0.9v 959.55n 0.9v 969.45n 0.9v 969.55n 0.9v 979.45n 0.9v 979.55n 0.9v 989.45n 0.9v 989.55n 0.9v 999.45n 0.9v 999.55n 0.0v 1009.45n 0.0v 1009.55n 0.0v 1019.45n 0.0v 1019.55n 0.0v 1029.45n 0.0v 1029.55n 0.0v 1039.45n 0.0v 1039.55n 0.0v 1049.45n 0.0v 1049.55n 0.0v 1059.45n 0.0v 1059.55n 0.0v 1069.45n 0.0v 1069.55n 0.0v 1079.45n 0.0v 1079.55n 0.0v 1089.45n 0.0v 1089.55n 0.0v 1099.45n 0.0v 1099.55n 0.0v 1109.45n 0.0v 1109.55n 0.0v 1119.45n 0.0v 1119.55n 0.0v 1129.45n 0.0v 1129.55n 0.0v 1139.45n 0.0v 1139.55n 0.0v 1149.45n 0.0v 1149.55n 0.0v 1159.45n 0.0v 1159.55n 0.0v 1169.45n 0.0v 1169.55n 0.0v 1179.45n 0.0v 1179.55n 0.0v 1189.45n 0.0v 1189.55n 0.0v 1199.45n 0.0v 1199.55n 0.0v 1209.45n 0.0v 1209.55n 0.0v 1219.45n 0.0v 1219.55n 0.0v 1229.45n 0.0v 1229.55n 0.9v 1239.45n 0.9v 1239.55n 0.0v 1249.45n 0.0v 1249.55n 0.0v 1259.45n 0.0v 1259.55n 0.0v 1269.45n 0.0v 1269.55n 0.0v 1279.45n 0.0v 1279.55n 0.0v 1289.45n 0.0v 1289.55n 0.9v 1299.45n 0.9v 1299.55n 0.9v 1309.45n 0.9v 1309.55n 0.9v 1319.45n 0.9v 1319.55n 0.9v 1329.45n 0.9v 1329.55n 0.0v 1339.45n 0.0v 1339.55n 0.0v 1349.45n 0.0v 1349.55n 0.9v 1359.45n 0.9v 1359.55n 0.9v 1369.45n 0.9v 1369.55n 0.0v 1379.45n 0.0v 1379.55n 0.0v 1389.45n 0.0v 1389.55n 0.0v 1399.45n 0.0v 1399.55n 0.0v 1409.45n 0.0v 1409.55n 0.0v 1419.45n 0.0v 1419.55n 0.0v 1429.45n 0.0v 1429.55n 0.0v 1439.45n 0.0v 1439.55n 0.0v 1449.45n 0.0v 1449.55n 0.0v 1459.45n 0.0v 1459.55n 0.9v 1469.45n 0.9v 1469.55n 0.0v 1479.45n 0.0v 1479.55n 0.0v 1489.45n 0.0v 1489.55n 0.0v 1499.45n 0.0v 1499.55n 0.0v 1509.45n 0.0v 1509.55n 0.0v 1519.45n 0.0v 1519.55n 0.0v 1529.45n 0.0v 1529.55n 0.0v 1539.45n 0.0v 1539.55n 0.0v 1549.45n 0.0v 1549.55n 0.0v 1559.45n 0.0v 1559.55n 0.0v 1569.45n 0.0v 1569.55n 0.0v 1579.45n 0.0v 1579.55n 0.0v 1589.45n 0.0v 1589.55n 0.0v 1599.45n 0.0v 1599.55n 0.0v 1609.45n 0.0v 1609.55n 0.0v 1619.45n 0.0v 1619.55n 0.9v 1629.45n 0.9v 1629.55n 0.9v 1639.45n 0.9v 1639.55n 0.9v 1649.45n 0.9v 1649.55n 0.9v 1659.45n 0.9v 1659.55n 0.9v 1669.45n 0.9v 1669.55n 0.9v 1679.45n 0.9v 1679.55n 0.9v 1689.45n 0.9v 1689.55n 0.9v 1699.45n 0.9v 1699.55n 0.9v 1709.45n 0.9v 1709.55n 0.9v 1719.45n 0.9v 1719.55n 0.9v 1729.45n 0.9v 1729.55n 0.9v 1739.45n 0.9v 1739.55n 0.9v 1749.45n 0.9v 1749.55n 0.9v 1759.45n 0.9v 1759.55n 0.9v 1769.45n 0.9v 1769.55n 0.9v 1779.45n 0.9v 1779.55n 0.9v 1789.45n 0.9v 1789.55n 0.9v 1799.45n 0.9v 1799.55n 0.9v 1809.45n 0.9v 1809.55n 0.9v 1819.45n 0.9v 1819.55n 0.9v 1829.45n 0.9v 1829.55n 0.9v 1839.45n 0.9v 1839.55n 0.9v 1849.45n 0.9v 1849.55n 0.0v 1859.45n 0.0v 1859.55n 0.0v 1869.45n 0.0v 1869.55n 0.0v 1879.45n 0.0v 1879.55n 0.0v 1889.45n 0.0v 1889.55n 0.9v 1899.45n 0.9v 1899.55n 0.9v 1909.45n 0.9v 1909.55n 0.0v 1919.45n 0.0v 1919.55n 0.0v 1929.45n 0.0v 1929.55n 0.0v 1939.45n 0.0v 1939.55n 0.0v 1949.45n 0.0v 1949.55n 0.0v 1959.45n 0.0v 1959.55n 0.0v 1969.45n 0.0v 1969.55n 0.0v 1979.45n 0.0v 1979.55n 0.0v 1989.45n 0.0v 1989.55n 0.0v 1999.45n 0.0v 1999.55n 0.0v 2009.45n 0.0v 2009.55n 0.0v 2019.45n 0.0v 2019.55n 0.0v 2029.45n 0.0v 2029.55n 0.0v 2039.45n 0.0v 2039.55n 0.0v 2049.45n 0.0v 2049.55n 0.0v )
* (time, data): [(0, 0), (10, 1), (20, 1), (30, 0), (40, 0), (50, 0), (60, 1), (70, 1), (80, 1), (90, 1), (100, 1), (110, 1), (120, 1), (130, 1), (140, 1), (150, 0), (160, 0), (170, 0), (180, 0), (190, 0), (200, 0), (210, 0), (220, 1), (230, 1), (240, 1), (250, 1), (260, 1), (270, 1), (280, 1), (290, 1), (300, 1), (310, 1), (320, 1), (330, 1), (340, 1), (350, 1), (360, 1), (370, 1), (380, 1), (390, 1), (400, 1), (410, 1), (420, 0), (430, 0), (440, 0), (450, 0), (460, 0), (470, 0), (480, 0), (490, 0), (500, 1), (510, 1), (520, 1), (530, 1), (540, 1), (550, 1), (560, 1), (570, 1), (580, 1), (590, 1), (600, 1), (610, 1), (620, 1), (630, 1), (640, 1), (650, 1), (660, 0), (670, 0), (680, 0), (690, 0), (700, 0), (710, 0), (720, 0), (730, 0), (740, 0), (750, 0), (760, 0), (770, 0), (780, 0), (790, 0), (800, 0), (810, 0), (820, 0), (830, 0), (840, 0), (850, 0), (860, 1), (870, 1), (880, 1), (890, 0), (900, 0), (910, 1), (920, 1), (930, 1), (940, 0), (950, 0), (960, 0), (970, 0), (980, 0), (990, 1), (1000, 0), (1010, 0), (1020, 0), (1030, 0), (1040, 0), (1050, 0), (1060, 0), (1070, 0), (1080, 0), (1090, 0), (1100, 0), (1110, 0), (1120, 0), (1130, 0), (1140, 0), (1150, 0), (1160, 0), (1170, 0), (1180, 0), (1190, 0), (1200, 0), (1210, 0), (1220, 0), (1230, 0), (1240, 0), (1250, 0), (1260, 0), (1270, 0), (1280, 0), (1290, 0), (1300, 0), (1310, 0), (1320, 0), (1330, 1), (1340, 1), (1350, 1), (1360, 1), (1370, 1), (1380, 1), (1390, 1), (1400, 1), (1410, 1), (1420, 1), (1430, 1), (1440, 1), (1450, 1), (1460, 0), (1470, 0), (1480, 0), (1490, 0), (1500, 0), (1510, 0), (1520, 0), (1530, 0), (1540, 0), (1550, 1), (1560, 1), (1570, 1), (1580, 1), (1590, 1), (1600, 1), (1610, 1), (1620, 1), (1630, 1), (1640, 1), (1650, 1), (1660, 1), (1670, 1), (1680, 1), (1690, 1), (1700, 1), (1710, 1), (1720, 1), (1730, 1), (1740, 1), (1750, 1), (1760, 1), (1770, 0), (1780, 0), (1790, 0), (1800, 0), (1810, 0), (1820, 0), (1830, 0), (1840, 0), (1850, 0), (1860, 0), (1870, 0), (1880, 0), (1890, 1), (1900, 1), (1910, 1), (1920, 1), (1930, 1), (1940, 0), (1950, 0), (1960, 0), (1970, 0), (1980, 0), (1990, 0), (2000, 0), (2010, 0), (2020, 0), (2030, 0), (2040, 0), (2050, 0)]
Vdin0_5  din0_5  0 PWL (0n 0.0v 9.45n 0.0v 9.55n 0.9v 19.45n 0.9v 19.55n 0.9v 29.45n 0.9v 29.55n 0.0v 39.45n 0.0v 39.55n 0.0v 49.45n 0.0v 49.55n 0.0v 59.45n 0.0v 59.55n 0.9v 69.45n 0.9v 69.55n 0.9v 79.45n 0.9v 79.55n 0.9v 89.45n 0.9v 89.55n 0.9v 99.45n 0.9v 99.55n 0.9v 109.45n 0.9v 109.55n 0.9v 119.45n 0.9v 119.55n 0.9v 129.45n 0.9v 129.55n 0.9v 139.45n 0.9v 139.55n 0.9v 149.45n 0.9v 149.55n 0.0v 159.45n 0.0v 159.55n 0.0v 169.45n 0.0v 169.55n 0.0v 179.45n 0.0v 179.55n 0.0v 189.45n 0.0v 189.55n 0.0v 199.45n 0.0v 199.55n 0.0v 209.45n 0.0v 209.55n 0.0v 219.45n 0.0v 219.55n 0.9v 229.45n 0.9v 229.55n 0.9v 239.45n 0.9v 239.55n 0.9v 249.45n 0.9v 249.55n 0.9v 259.45n 0.9v 259.55n 0.9v 269.45n 0.9v 269.55n 0.9v 279.45n 0.9v 279.55n 0.9v 289.45n 0.9v 289.55n 0.9v 299.45n 0.9v 299.55n 0.9v 309.45n 0.9v 309.55n 0.9v 319.45n 0.9v 319.55n 0.9v 329.45n 0.9v 329.55n 0.9v 339.45n 0.9v 339.55n 0.9v 349.45n 0.9v 349.55n 0.9v 359.45n 0.9v 359.55n 0.9v 369.45n 0.9v 369.55n 0.9v 379.45n 0.9v 379.55n 0.9v 389.45n 0.9v 389.55n 0.9v 399.45n 0.9v 399.55n 0.9v 409.45n 0.9v 409.55n 0.9v 419.45n 0.9v 419.55n 0.0v 429.45n 0.0v 429.55n 0.0v 439.45n 0.0v 439.55n 0.0v 449.45n 0.0v 449.55n 0.0v 459.45n 0.0v 459.55n 0.0v 469.45n 0.0v 469.55n 0.0v 479.45n 0.0v 479.55n 0.0v 489.45n 0.0v 489.55n 0.0v 499.45n 0.0v 499.55n 0.9v 509.45n 0.9v 509.55n 0.9v 519.45n 0.9v 519.55n 0.9v 529.45n 0.9v 529.55n 0.9v 539.45n 0.9v 539.55n 0.9v 549.45n 0.9v 549.55n 0.9v 559.45n 0.9v 559.55n 0.9v 569.45n 0.9v 569.55n 0.9v 579.45n 0.9v 579.55n 0.9v 589.45n 0.9v 589.55n 0.9v 599.45n 0.9v 599.55n 0.9v 609.45n 0.9v 609.55n 0.9v 619.45n 0.9v 619.55n 0.9v 629.45n 0.9v 629.55n 0.9v 639.45n 0.9v 639.55n 0.9v 649.45n 0.9v 649.55n 0.9v 659.45n 0.9v 659.55n 0.0v 669.45n 0.0v 669.55n 0.0v 679.45n 0.0v 679.55n 0.0v 689.45n 0.0v 689.55n 0.0v 699.45n 0.0v 699.55n 0.0v 709.45n 0.0v 709.55n 0.0v 719.45n 0.0v 719.55n 0.0v 729.45n 0.0v 729.55n 0.0v 739.45n 0.0v 739.55n 0.0v 749.45n 0.0v 749.55n 0.0v 759.45n 0.0v 759.55n 0.0v 769.45n 0.0v 769.55n 0.0v 779.45n 0.0v 779.55n 0.0v 789.45n 0.0v 789.55n 0.0v 799.45n 0.0v 799.55n 0.0v 809.45n 0.0v 809.55n 0.0v 819.45n 0.0v 819.55n 0.0v 829.45n 0.0v 829.55n 0.0v 839.45n 0.0v 839.55n 0.0v 849.45n 0.0v 849.55n 0.0v 859.45n 0.0v 859.55n 0.9v 869.45n 0.9v 869.55n 0.9v 879.45n 0.9v 879.55n 0.9v 889.45n 0.9v 889.55n 0.0v 899.45n 0.0v 899.55n 0.0v 909.45n 0.0v 909.55n 0.9v 919.45n 0.9v 919.55n 0.9v 929.45n 0.9v 929.55n 0.9v 939.45n 0.9v 939.55n 0.0v 949.45n 0.0v 949.55n 0.0v 959.45n 0.0v 959.55n 0.0v 969.45n 0.0v 969.55n 0.0v 979.45n 0.0v 979.55n 0.0v 989.45n 0.0v 989.55n 0.9v 999.45n 0.9v 999.55n 0.0v 1009.45n 0.0v 1009.55n 0.0v 1019.45n 0.0v 1019.55n 0.0v 1029.45n 0.0v 1029.55n 0.0v 1039.45n 0.0v 1039.55n 0.0v 1049.45n 0.0v 1049.55n 0.0v 1059.45n 0.0v 1059.55n 0.0v 1069.45n 0.0v 1069.55n 0.0v 1079.45n 0.0v 1079.55n 0.0v 1089.45n 0.0v 1089.55n 0.0v 1099.45n 0.0v 1099.55n 0.0v 1109.45n 0.0v 1109.55n 0.0v 1119.45n 0.0v 1119.55n 0.0v 1129.45n 0.0v 1129.55n 0.0v 1139.45n 0.0v 1139.55n 0.0v 1149.45n 0.0v 1149.55n 0.0v 1159.45n 0.0v 1159.55n 0.0v 1169.45n 0.0v 1169.55n 0.0v 1179.45n 0.0v 1179.55n 0.0v 1189.45n 0.0v 1189.55n 0.0v 1199.45n 0.0v 1199.55n 0.0v 1209.45n 0.0v 1209.55n 0.0v 1219.45n 0.0v 1219.55n 0.0v 1229.45n 0.0v 1229.55n 0.0v 1239.45n 0.0v 1239.55n 0.0v 1249.45n 0.0v 1249.55n 0.0v 1259.45n 0.0v 1259.55n 0.0v 1269.45n 0.0v 1269.55n 0.0v 1279.45n 0.0v 1279.55n 0.0v 1289.45n 0.0v 1289.55n 0.0v 1299.45n 0.0v 1299.55n 0.0v 1309.45n 0.0v 1309.55n 0.0v 1319.45n 0.0v 1319.55n 0.0v 1329.45n 0.0v 1329.55n 0.9v 1339.45n 0.9v 1339.55n 0.9v 1349.45n 0.9v 1349.55n 0.9v 1359.45n 0.9v 1359.55n 0.9v 1369.45n 0.9v 1369.55n 0.9v 1379.45n 0.9v 1379.55n 0.9v 1389.45n 0.9v 1389.55n 0.9v 1399.45n 0.9v 1399.55n 0.9v 1409.45n 0.9v 1409.55n 0.9v 1419.45n 0.9v 1419.55n 0.9v 1429.45n 0.9v 1429.55n 0.9v 1439.45n 0.9v 1439.55n 0.9v 1449.45n 0.9v 1449.55n 0.9v 1459.45n 0.9v 1459.55n 0.0v 1469.45n 0.0v 1469.55n 0.0v 1479.45n 0.0v 1479.55n 0.0v 1489.45n 0.0v 1489.55n 0.0v 1499.45n 0.0v 1499.55n 0.0v 1509.45n 0.0v 1509.55n 0.0v 1519.45n 0.0v 1519.55n 0.0v 1529.45n 0.0v 1529.55n 0.0v 1539.45n 0.0v 1539.55n 0.0v 1549.45n 0.0v 1549.55n 0.9v 1559.45n 0.9v 1559.55n 0.9v 1569.45n 0.9v 1569.55n 0.9v 1579.45n 0.9v 1579.55n 0.9v 1589.45n 0.9v 1589.55n 0.9v 1599.45n 0.9v 1599.55n 0.9v 1609.45n 0.9v 1609.55n 0.9v 1619.45n 0.9v 1619.55n 0.9v 1629.45n 0.9v 1629.55n 0.9v 1639.45n 0.9v 1639.55n 0.9v 1649.45n 0.9v 1649.55n 0.9v 1659.45n 0.9v 1659.55n 0.9v 1669.45n 0.9v 1669.55n 0.9v 1679.45n 0.9v 1679.55n 0.9v 1689.45n 0.9v 1689.55n 0.9v 1699.45n 0.9v 1699.55n 0.9v 1709.45n 0.9v 1709.55n 0.9v 1719.45n 0.9v 1719.55n 0.9v 1729.45n 0.9v 1729.55n 0.9v 1739.45n 0.9v 1739.55n 0.9v 1749.45n 0.9v 1749.55n 0.9v 1759.45n 0.9v 1759.55n 0.9v 1769.45n 0.9v 1769.55n 0.0v 1779.45n 0.0v 1779.55n 0.0v 1789.45n 0.0v 1789.55n 0.0v 1799.45n 0.0v 1799.55n 0.0v 1809.45n 0.0v 1809.55n 0.0v 1819.45n 0.0v 1819.55n 0.0v 1829.45n 0.0v 1829.55n 0.0v 1839.45n 0.0v 1839.55n 0.0v 1849.45n 0.0v 1849.55n 0.0v 1859.45n 0.0v 1859.55n 0.0v 1869.45n 0.0v 1869.55n 0.0v 1879.45n 0.0v 1879.55n 0.0v 1889.45n 0.0v 1889.55n 0.9v 1899.45n 0.9v 1899.55n 0.9v 1909.45n 0.9v 1909.55n 0.9v 1919.45n 0.9v 1919.55n 0.9v 1929.45n 0.9v 1929.55n 0.9v 1939.45n 0.9v 1939.55n 0.0v 1949.45n 0.0v 1949.55n 0.0v 1959.45n 0.0v 1959.55n 0.0v 1969.45n 0.0v 1969.55n 0.0v 1979.45n 0.0v 1979.55n 0.0v 1989.45n 0.0v 1989.55n 0.0v 1999.45n 0.0v 1999.55n 0.0v 2009.45n 0.0v 2009.55n 0.0v 2019.45n 0.0v 2019.55n 0.0v 2029.45n 0.0v 2029.55n 0.0v 2039.45n 0.0v 2039.55n 0.0v 2049.45n 0.0v 2049.55n 0.0v )
* (time, data): [(0, 0), (10, 1), (20, 1), (30, 0), (40, 0), (50, 0), (60, 1), (70, 0), (80, 1), (90, 0), (100, 0), (110, 0), (120, 0), (130, 0), (140, 0), (150, 1), (160, 1), (170, 1), (180, 1), (190, 1), (200, 1), (210, 1), (220, 0), (230, 0), (240, 0), (250, 0), (260, 0), (270, 0), (280, 0), (290, 0), (300, 0), (310, 0), (320, 0), (330, 0), (340, 0), (350, 0), (360, 0), (370, 0), (380, 0), (390, 0), (400, 0), (410, 0), (420, 0), (430, 0), (440, 0), (450, 0), (460, 0), (470, 0), (480, 0), (490, 0), (500, 1), (510, 1), (520, 1), (530, 1), (540, 0), (550, 0), (560, 0), (570, 0), (580, 0), (590, 0), (600, 0), (610, 1), (620, 1), (630, 1), (640, 0), (650, 0), (660, 1), (670, 1), (680, 1), (690, 1), (700, 0), (710, 0), (720, 0), (730, 0), (740, 0), (750, 0), (760, 0), (770, 0), (780, 0), (790, 1), (800, 0), (810, 0), (820, 0), (830, 0), (840, 0), (850, 0), (860, 0), (870, 0), (880, 0), (890, 1), (900, 1), (910, 0), (920, 0), (930, 0), (940, 1), (950, 1), (960, 1), (970, 1), (980, 1), (990, 0), (1000, 1), (1010, 1), (1020, 1), (1030, 1), (1040, 1), (1050, 1), (1060, 0), (1070, 0), (1080, 0), (1090, 0), (1100, 0), (1110, 0), (1120, 0), (1130, 0), (1140, 0), (1150, 0), (1160, 0), (1170, 0), (1180, 0), (1190, 0), (1200, 0), (1210, 0), (1220, 0), (1230, 0), (1240, 0), (1250, 0), (1260, 0), (1270, 0), (1280, 0), (1290, 0), (1300, 0), (1310, 0), (1320, 0), (1330, 1), (1340, 1), (1350, 1), (1360, 1), (1370, 1), (1380, 1), (1390, 1), (1400, 1), (1410, 1), (1420, 1), (1430, 1), (1440, 1), (1450, 1), (1460, 1), (1470, 0), (1480, 0), (1490, 0), (1500, 0), (1510, 0), (1520, 0), (1530, 0), (1540, 0), (1550, 1), (1560, 1), (1570, 1), (1580, 1), (1590, 1), (1600, 1), (1610, 1), (1620, 1), (1630, 1), (1640, 1), (1650, 1), (1660, 1), (1670, 1), (1680, 1), (1690, 1), (1700, 1), (1710, 1), (1720, 0), (1730, 0), (1740, 0), (1750, 0), (1760, 0), (1770, 1), (1780, 1), (1790, 1), (1800, 1), (1810, 1), (1820, 1), (1830, 1), (1840, 1), (1850, 0), (1860, 0), (1870, 0), (1880, 0), (1890, 1), (1900, 1), (1910, 1), (1920, 1), (1930, 1), (1940, 0), (1950, 0), (1960, 0), (1970, 0), (1980, 0), (1990, 0), (2000, 0), (2010, 0), (2020, 0), (2030, 0), (2040, 0), (2050, 0)]
Vdin0_6  din0_6  0 PWL (0n 0.0v 9.45n 0.0v 9.55n 0.9v 19.45n 0.9v 19.55n 0.9v 29.45n 0.9v 29.55n 0.0v 39.45n 0.0v 39.55n 0.0v 49.45n 0.0v 49.55n 0.0v 59.45n 0.0v 59.55n 0.9v 69.45n 0.9v 69.55n 0.0v 79.45n 0.0v 79.55n 0.9v 89.45n 0.9v 89.55n 0.0v 99.45n 0.0v 99.55n 0.0v 109.45n 0.0v 109.55n 0.0v 119.45n 0.0v 119.55n 0.0v 129.45n 0.0v 129.55n 0.0v 139.45n 0.0v 139.55n 0.0v 149.45n 0.0v 149.55n 0.9v 159.45n 0.9v 159.55n 0.9v 169.45n 0.9v 169.55n 0.9v 179.45n 0.9v 179.55n 0.9v 189.45n 0.9v 189.55n 0.9v 199.45n 0.9v 199.55n 0.9v 209.45n 0.9v 209.55n 0.9v 219.45n 0.9v 219.55n 0.0v 229.45n 0.0v 229.55n 0.0v 239.45n 0.0v 239.55n 0.0v 249.45n 0.0v 249.55n 0.0v 259.45n 0.0v 259.55n 0.0v 269.45n 0.0v 269.55n 0.0v 279.45n 0.0v 279.55n 0.0v 289.45n 0.0v 289.55n 0.0v 299.45n 0.0v 299.55n 0.0v 309.45n 0.0v 309.55n 0.0v 319.45n 0.0v 319.55n 0.0v 329.45n 0.0v 329.55n 0.0v 339.45n 0.0v 339.55n 0.0v 349.45n 0.0v 349.55n 0.0v 359.45n 0.0v 359.55n 0.0v 369.45n 0.0v 369.55n 0.0v 379.45n 0.0v 379.55n 0.0v 389.45n 0.0v 389.55n 0.0v 399.45n 0.0v 399.55n 0.0v 409.45n 0.0v 409.55n 0.0v 419.45n 0.0v 419.55n 0.0v 429.45n 0.0v 429.55n 0.0v 439.45n 0.0v 439.55n 0.0v 449.45n 0.0v 449.55n 0.0v 459.45n 0.0v 459.55n 0.0v 469.45n 0.0v 469.55n 0.0v 479.45n 0.0v 479.55n 0.0v 489.45n 0.0v 489.55n 0.0v 499.45n 0.0v 499.55n 0.9v 509.45n 0.9v 509.55n 0.9v 519.45n 0.9v 519.55n 0.9v 529.45n 0.9v 529.55n 0.9v 539.45n 0.9v 539.55n 0.0v 549.45n 0.0v 549.55n 0.0v 559.45n 0.0v 559.55n 0.0v 569.45n 0.0v 569.55n 0.0v 579.45n 0.0v 579.55n 0.0v 589.45n 0.0v 589.55n 0.0v 599.45n 0.0v 599.55n 0.0v 609.45n 0.0v 609.55n 0.9v 619.45n 0.9v 619.55n 0.9v 629.45n 0.9v 629.55n 0.9v 639.45n 0.9v 639.55n 0.0v 649.45n 0.0v 649.55n 0.0v 659.45n 0.0v 659.55n 0.9v 669.45n 0.9v 669.55n 0.9v 679.45n 0.9v 679.55n 0.9v 689.45n 0.9v 689.55n 0.9v 699.45n 0.9v 699.55n 0.0v 709.45n 0.0v 709.55n 0.0v 719.45n 0.0v 719.55n 0.0v 729.45n 0.0v 729.55n 0.0v 739.45n 0.0v 739.55n 0.0v 749.45n 0.0v 749.55n 0.0v 759.45n 0.0v 759.55n 0.0v 769.45n 0.0v 769.55n 0.0v 779.45n 0.0v 779.55n 0.0v 789.45n 0.0v 789.55n 0.9v 799.45n 0.9v 799.55n 0.0v 809.45n 0.0v 809.55n 0.0v 819.45n 0.0v 819.55n 0.0v 829.45n 0.0v 829.55n 0.0v 839.45n 0.0v 839.55n 0.0v 849.45n 0.0v 849.55n 0.0v 859.45n 0.0v 859.55n 0.0v 869.45n 0.0v 869.55n 0.0v 879.45n 0.0v 879.55n 0.0v 889.45n 0.0v 889.55n 0.9v 899.45n 0.9v 899.55n 0.9v 909.45n 0.9v 909.55n 0.0v 919.45n 0.0v 919.55n 0.0v 929.45n 0.0v 929.55n 0.0v 939.45n 0.0v 939.55n 0.9v 949.45n 0.9v 949.55n 0.9v 959.45n 0.9v 959.55n 0.9v 969.45n 0.9v 969.55n 0.9v 979.45n 0.9v 979.55n 0.9v 989.45n 0.9v 989.55n 0.0v 999.45n 0.0v 999.55n 0.9v 1009.45n 0.9v 1009.55n 0.9v 1019.45n 0.9v 1019.55n 0.9v 1029.45n 0.9v 1029.55n 0.9v 1039.45n 0.9v 1039.55n 0.9v 1049.45n 0.9v 1049.55n 0.9v 1059.45n 0.9v 1059.55n 0.0v 1069.45n 0.0v 1069.55n 0.0v 1079.45n 0.0v 1079.55n 0.0v 1089.45n 0.0v 1089.55n 0.0v 1099.45n 0.0v 1099.55n 0.0v 1109.45n 0.0v 1109.55n 0.0v 1119.45n 0.0v 1119.55n 0.0v 1129.45n 0.0v 1129.55n 0.0v 1139.45n 0.0v 1139.55n 0.0v 1149.45n 0.0v 1149.55n 0.0v 1159.45n 0.0v 1159.55n 0.0v 1169.45n 0.0v 1169.55n 0.0v 1179.45n 0.0v 1179.55n 0.0v 1189.45n 0.0v 1189.55n 0.0v 1199.45n 0.0v 1199.55n 0.0v 1209.45n 0.0v 1209.55n 0.0v 1219.45n 0.0v 1219.55n 0.0v 1229.45n 0.0v 1229.55n 0.0v 1239.45n 0.0v 1239.55n 0.0v 1249.45n 0.0v 1249.55n 0.0v 1259.45n 0.0v 1259.55n 0.0v 1269.45n 0.0v 1269.55n 0.0v 1279.45n 0.0v 1279.55n 0.0v 1289.45n 0.0v 1289.55n 0.0v 1299.45n 0.0v 1299.55n 0.0v 1309.45n 0.0v 1309.55n 0.0v 1319.45n 0.0v 1319.55n 0.0v 1329.45n 0.0v 1329.55n 0.9v 1339.45n 0.9v 1339.55n 0.9v 1349.45n 0.9v 1349.55n 0.9v 1359.45n 0.9v 1359.55n 0.9v 1369.45n 0.9v 1369.55n 0.9v 1379.45n 0.9v 1379.55n 0.9v 1389.45n 0.9v 1389.55n 0.9v 1399.45n 0.9v 1399.55n 0.9v 1409.45n 0.9v 1409.55n 0.9v 1419.45n 0.9v 1419.55n 0.9v 1429.45n 0.9v 1429.55n 0.9v 1439.45n 0.9v 1439.55n 0.9v 1449.45n 0.9v 1449.55n 0.9v 1459.45n 0.9v 1459.55n 0.9v 1469.45n 0.9v 1469.55n 0.0v 1479.45n 0.0v 1479.55n 0.0v 1489.45n 0.0v 1489.55n 0.0v 1499.45n 0.0v 1499.55n 0.0v 1509.45n 0.0v 1509.55n 0.0v 1519.45n 0.0v 1519.55n 0.0v 1529.45n 0.0v 1529.55n 0.0v 1539.45n 0.0v 1539.55n 0.0v 1549.45n 0.0v 1549.55n 0.9v 1559.45n 0.9v 1559.55n 0.9v 1569.45n 0.9v 1569.55n 0.9v 1579.45n 0.9v 1579.55n 0.9v 1589.45n 0.9v 1589.55n 0.9v 1599.45n 0.9v 1599.55n 0.9v 1609.45n 0.9v 1609.55n 0.9v 1619.45n 0.9v 1619.55n 0.9v 1629.45n 0.9v 1629.55n 0.9v 1639.45n 0.9v 1639.55n 0.9v 1649.45n 0.9v 1649.55n 0.9v 1659.45n 0.9v 1659.55n 0.9v 1669.45n 0.9v 1669.55n 0.9v 1679.45n 0.9v 1679.55n 0.9v 1689.45n 0.9v 1689.55n 0.9v 1699.45n 0.9v 1699.55n 0.9v 1709.45n 0.9v 1709.55n 0.9v 1719.45n 0.9v 1719.55n 0.0v 1729.45n 0.0v 1729.55n 0.0v 1739.45n 0.0v 1739.55n 0.0v 1749.45n 0.0v 1749.55n 0.0v 1759.45n 0.0v 1759.55n 0.0v 1769.45n 0.0v 1769.55n 0.9v 1779.45n 0.9v 1779.55n 0.9v 1789.45n 0.9v 1789.55n 0.9v 1799.45n 0.9v 1799.55n 0.9v 1809.45n 0.9v 1809.55n 0.9v 1819.45n 0.9v 1819.55n 0.9v 1829.45n 0.9v 1829.55n 0.9v 1839.45n 0.9v 1839.55n 0.9v 1849.45n 0.9v 1849.55n 0.0v 1859.45n 0.0v 1859.55n 0.0v 1869.45n 0.0v 1869.55n 0.0v 1879.45n 0.0v 1879.55n 0.0v 1889.45n 0.0v 1889.55n 0.9v 1899.45n 0.9v 1899.55n 0.9v 1909.45n 0.9v 1909.55n 0.9v 1919.45n 0.9v 1919.55n 0.9v 1929.45n 0.9v 1929.55n 0.9v 1939.45n 0.9v 1939.55n 0.0v 1949.45n 0.0v 1949.55n 0.0v 1959.45n 0.0v 1959.55n 0.0v 1969.45n 0.0v 1969.55n 0.0v 1979.45n 0.0v 1979.55n 0.0v 1989.45n 0.0v 1989.55n 0.0v 1999.45n 0.0v 1999.55n 0.0v 2009.45n 0.0v 2009.55n 0.0v 2019.45n 0.0v 2019.55n 0.0v 2029.45n 0.0v 2029.55n 0.0v 2039.45n 0.0v 2039.55n 0.0v 2049.45n 0.0v 2049.55n 0.0v )
* (time, data): [(0, 0), (10, 0), (20, 1), (30, 0), (40, 0), (50, 0), (60, 0), (70, 1), (80, 1), (90, 0), (100, 0), (110, 0), (120, 0), (130, 0), (140, 0), (150, 0), (160, 1), (170, 1), (180, 1), (190, 1), (200, 1), (210, 1), (220, 1), (230, 1), (240, 1), (250, 1), (260, 1), (270, 1), (280, 1), (290, 1), (300, 1), (310, 1), (320, 1), (330, 1), (340, 1), (350, 1), (360, 1), (370, 1), (380, 1), (390, 1), (400, 0), (410, 0), (420, 1), (430, 1), (440, 1), (450, 1), (460, 1), (470, 1), (480, 1), (490, 1), (500, 0), (510, 0), (520, 0), (530, 0), (540, 1), (550, 1), (560, 1), (570, 1), (580, 1), (590, 1), (600, 1), (610, 0), (620, 0), (630, 0), (640, 0), (650, 0), (660, 0), (670, 0), (680, 0), (690, 0), (700, 0), (710, 0), (720, 0), (730, 0), (740, 0), (750, 0), (760, 0), (770, 0), (780, 0), (790, 0), (800, 0), (810, 1), (820, 1), (830, 1), (840, 1), (850, 1), (860, 1), (870, 1), (880, 1), (890, 0), (900, 0), (910, 1), (920, 1), (930, 1), (940, 1), (950, 1), (960, 0), (970, 0), (980, 0), (990, 1), (1000, 1), (1010, 1), (1020, 1), (1030, 1), (1040, 1), (1050, 1), (1060, 0), (1070, 0), (1080, 0), (1090, 0), (1100, 0), (1110, 0), (1120, 0), (1130, 0), (1140, 0), (1150, 0), (1160, 0), (1170, 0), (1180, 0), (1190, 0), (1200, 0), (1210, 0), (1220, 0), (1230, 1), (1240, 1), (1250, 1), (1260, 1), (1270, 1), (1280, 1), (1290, 0), (1300, 1), (1310, 1), (1320, 1), (1330, 1), (1340, 1), (1350, 1), (1360, 1), (1370, 0), (1380, 0), (1390, 0), (1400, 0), (1410, 0), (1420, 0), (1430, 0), (1440, 0), (1450, 0), (1460, 1), (1470, 0), (1480, 0), (1490, 0), (1500, 0), (1510, 0), (1520, 0), (1530, 0), (1540, 0), (1550, 0), (1560, 0), (1570, 0), (1580, 0), (1590, 0), (1600, 0), (1610, 0), (1620, 0), (1630, 0), (1640, 0), (1650, 0), (1660, 0), (1670, 0), (1680, 0), (1690, 0), (1700, 0), (1710, 0), (1720, 0), (1730, 0), (1740, 0), (1750, 0), (1760, 0), (1770, 1), (1780, 1), (1790, 1), (1800, 1), (1810, 1), (1820, 1), (1830, 1), (1840, 1), (1850, 0), (1860, 0), (1870, 0), (1880, 0), (1890, 0), (1900, 0), (1910, 1), (1920, 1), (1930, 1), (1940, 1), (1950, 1), (1960, 1), (1970, 1), (1980, 1), (1990, 1), (2000, 1), (2010, 1), (2020, 1), (2030, 1), (2040, 1), (2050, 1)]
Vdin0_7  din0_7  0 PWL (0n 0.0v 9.45n 0.0v 9.55n 0.0v 19.45n 0.0v 19.55n 0.9v 29.45n 0.9v 29.55n 0.0v 39.45n 0.0v 39.55n 0.0v 49.45n 0.0v 49.55n 0.0v 59.45n 0.0v 59.55n 0.0v 69.45n 0.0v 69.55n 0.9v 79.45n 0.9v 79.55n 0.9v 89.45n 0.9v 89.55n 0.0v 99.45n 0.0v 99.55n 0.0v 109.45n 0.0v 109.55n 0.0v 119.45n 0.0v 119.55n 0.0v 129.45n 0.0v 129.55n 0.0v 139.45n 0.0v 139.55n 0.0v 149.45n 0.0v 149.55n 0.0v 159.45n 0.0v 159.55n 0.9v 169.45n 0.9v 169.55n 0.9v 179.45n 0.9v 179.55n 0.9v 189.45n 0.9v 189.55n 0.9v 199.45n 0.9v 199.55n 0.9v 209.45n 0.9v 209.55n 0.9v 219.45n 0.9v 219.55n 0.9v 229.45n 0.9v 229.55n 0.9v 239.45n 0.9v 239.55n 0.9v 249.45n 0.9v 249.55n 0.9v 259.45n 0.9v 259.55n 0.9v 269.45n 0.9v 269.55n 0.9v 279.45n 0.9v 279.55n 0.9v 289.45n 0.9v 289.55n 0.9v 299.45n 0.9v 299.55n 0.9v 309.45n 0.9v 309.55n 0.9v 319.45n 0.9v 319.55n 0.9v 329.45n 0.9v 329.55n 0.9v 339.45n 0.9v 339.55n 0.9v 349.45n 0.9v 349.55n 0.9v 359.45n 0.9v 359.55n 0.9v 369.45n 0.9v 369.55n 0.9v 379.45n 0.9v 379.55n 0.9v 389.45n 0.9v 389.55n 0.9v 399.45n 0.9v 399.55n 0.0v 409.45n 0.0v 409.55n 0.0v 419.45n 0.0v 419.55n 0.9v 429.45n 0.9v 429.55n 0.9v 439.45n 0.9v 439.55n 0.9v 449.45n 0.9v 449.55n 0.9v 459.45n 0.9v 459.55n 0.9v 469.45n 0.9v 469.55n 0.9v 479.45n 0.9v 479.55n 0.9v 489.45n 0.9v 489.55n 0.9v 499.45n 0.9v 499.55n 0.0v 509.45n 0.0v 509.55n 0.0v 519.45n 0.0v 519.55n 0.0v 529.45n 0.0v 529.55n 0.0v 539.45n 0.0v 539.55n 0.9v 549.45n 0.9v 549.55n 0.9v 559.45n 0.9v 559.55n 0.9v 569.45n 0.9v 569.55n 0.9v 579.45n 0.9v 579.55n 0.9v 589.45n 0.9v 589.55n 0.9v 599.45n 0.9v 599.55n 0.9v 609.45n 0.9v 609.55n 0.0v 619.45n 0.0v 619.55n 0.0v 629.45n 0.0v 629.55n 0.0v 639.45n 0.0v 639.55n 0.0v 649.45n 0.0v 649.55n 0.0v 659.45n 0.0v 659.55n 0.0v 669.45n 0.0v 669.55n 0.0v 679.45n 0.0v 679.55n 0.0v 689.45n 0.0v 689.55n 0.0v 699.45n 0.0v 699.55n 0.0v 709.45n 0.0v 709.55n 0.0v 719.45n 0.0v 719.55n 0.0v 729.45n 0.0v 729.55n 0.0v 739.45n 0.0v 739.55n 0.0v 749.45n 0.0v 749.55n 0.0v 759.45n 0.0v 759.55n 0.0v 769.45n 0.0v 769.55n 0.0v 779.45n 0.0v 779.55n 0.0v 789.45n 0.0v 789.55n 0.0v 799.45n 0.0v 799.55n 0.0v 809.45n 0.0v 809.55n 0.9v 819.45n 0.9v 819.55n 0.9v 829.45n 0.9v 829.55n 0.9v 839.45n 0.9v 839.55n 0.9v 849.45n 0.9v 849.55n 0.9v 859.45n 0.9v 859.55n 0.9v 869.45n 0.9v 869.55n 0.9v 879.45n 0.9v 879.55n 0.9v 889.45n 0.9v 889.55n 0.0v 899.45n 0.0v 899.55n 0.0v 909.45n 0.0v 909.55n 0.9v 919.45n 0.9v 919.55n 0.9v 929.45n 0.9v 929.55n 0.9v 939.45n 0.9v 939.55n 0.9v 949.45n 0.9v 949.55n 0.9v 959.45n 0.9v 959.55n 0.0v 969.45n 0.0v 969.55n 0.0v 979.45n 0.0v 979.55n 0.0v 989.45n 0.0v 989.55n 0.9v 999.45n 0.9v 999.55n 0.9v 1009.45n 0.9v 1009.55n 0.9v 1019.45n 0.9v 1019.55n 0.9v 1029.45n 0.9v 1029.55n 0.9v 1039.45n 0.9v 1039.55n 0.9v 1049.45n 0.9v 1049.55n 0.9v 1059.45n 0.9v 1059.55n 0.0v 1069.45n 0.0v 1069.55n 0.0v 1079.45n 0.0v 1079.55n 0.0v 1089.45n 0.0v 1089.55n 0.0v 1099.45n 0.0v 1099.55n 0.0v 1109.45n 0.0v 1109.55n 0.0v 1119.45n 0.0v 1119.55n 0.0v 1129.45n 0.0v 1129.55n 0.0v 1139.45n 0.0v 1139.55n 0.0v 1149.45n 0.0v 1149.55n 0.0v 1159.45n 0.0v 1159.55n 0.0v 1169.45n 0.0v 1169.55n 0.0v 1179.45n 0.0v 1179.55n 0.0v 1189.45n 0.0v 1189.55n 0.0v 1199.45n 0.0v 1199.55n 0.0v 1209.45n 0.0v 1209.55n 0.0v 1219.45n 0.0v 1219.55n 0.0v 1229.45n 0.0v 1229.55n 0.9v 1239.45n 0.9v 1239.55n 0.9v 1249.45n 0.9v 1249.55n 0.9v 1259.45n 0.9v 1259.55n 0.9v 1269.45n 0.9v 1269.55n 0.9v 1279.45n 0.9v 1279.55n 0.9v 1289.45n 0.9v 1289.55n 0.0v 1299.45n 0.0v 1299.55n 0.9v 1309.45n 0.9v 1309.55n 0.9v 1319.45n 0.9v 1319.55n 0.9v 1329.45n 0.9v 1329.55n 0.9v 1339.45n 0.9v 1339.55n 0.9v 1349.45n 0.9v 1349.55n 0.9v 1359.45n 0.9v 1359.55n 0.9v 1369.45n 0.9v 1369.55n 0.0v 1379.45n 0.0v 1379.55n 0.0v 1389.45n 0.0v 1389.55n 0.0v 1399.45n 0.0v 1399.55n 0.0v 1409.45n 0.0v 1409.55n 0.0v 1419.45n 0.0v 1419.55n 0.0v 1429.45n 0.0v 1429.55n 0.0v 1439.45n 0.0v 1439.55n 0.0v 1449.45n 0.0v 1449.55n 0.0v 1459.45n 0.0v 1459.55n 0.9v 1469.45n 0.9v 1469.55n 0.0v 1479.45n 0.0v 1479.55n 0.0v 1489.45n 0.0v 1489.55n 0.0v 1499.45n 0.0v 1499.55n 0.0v 1509.45n 0.0v 1509.55n 0.0v 1519.45n 0.0v 1519.55n 0.0v 1529.45n 0.0v 1529.55n 0.0v 1539.45n 0.0v 1539.55n 0.0v 1549.45n 0.0v 1549.55n 0.0v 1559.45n 0.0v 1559.55n 0.0v 1569.45n 0.0v 1569.55n 0.0v 1579.45n 0.0v 1579.55n 0.0v 1589.45n 0.0v 1589.55n 0.0v 1599.45n 0.0v 1599.55n 0.0v 1609.45n 0.0v 1609.55n 0.0v 1619.45n 0.0v 1619.55n 0.0v 1629.45n 0.0v 1629.55n 0.0v 1639.45n 0.0v 1639.55n 0.0v 1649.45n 0.0v 1649.55n 0.0v 1659.45n 0.0v 1659.55n 0.0v 1669.45n 0.0v 1669.55n 0.0v 1679.45n 0.0v 1679.55n 0.0v 1689.45n 0.0v 1689.55n 0.0v 1699.45n 0.0v 1699.55n 0.0v 1709.45n 0.0v 1709.55n 0.0v 1719.45n 0.0v 1719.55n 0.0v 1729.45n 0.0v 1729.55n 0.0v 1739.45n 0.0v 1739.55n 0.0v 1749.45n 0.0v 1749.55n 0.0v 1759.45n 0.0v 1759.55n 0.0v 1769.45n 0.0v 1769.55n 0.9v 1779.45n 0.9v 1779.55n 0.9v 1789.45n 0.9v 1789.55n 0.9v 1799.45n 0.9v 1799.55n 0.9v 1809.45n 0.9v 1809.55n 0.9v 1819.45n 0.9v 1819.55n 0.9v 1829.45n 0.9v 1829.55n 0.9v 1839.45n 0.9v 1839.55n 0.9v 1849.45n 0.9v 1849.55n 0.0v 1859.45n 0.0v 1859.55n 0.0v 1869.45n 0.0v 1869.55n 0.0v 1879.45n 0.0v 1879.55n 0.0v 1889.45n 0.0v 1889.55n 0.0v 1899.45n 0.0v 1899.55n 0.0v 1909.45n 0.0v 1909.55n 0.9v 1919.45n 0.9v 1919.55n 0.9v 1929.45n 0.9v 1929.55n 0.9v 1939.45n 0.9v 1939.55n 0.9v 1949.45n 0.9v 1949.55n 0.9v 1959.45n 0.9v 1959.55n 0.9v 1969.45n 0.9v 1969.55n 0.9v 1979.45n 0.9v 1979.55n 0.9v 1989.45n 0.9v 1989.55n 0.9v 1999.45n 0.9v 1999.55n 0.9v 2009.45n 0.9v 2009.55n 0.9v 2019.45n 0.9v 2019.55n 0.9v 2029.45n 0.9v 2029.55n 0.9v 2039.45n 0.9v 2039.55n 0.9v 2049.45n 0.9v 2049.55n 0.9v )
* (time, data): [(0, 0), (10, 0), (20, 0), (30, 0), (40, 0), (50, 0), (60, 0), (70, 0), (80, 0), (90, 0), (100, 0), (110, 0), (120, 0), (130, 0), (140, 0), (150, 0), (160, 0), (170, 0), (180, 0), (190, 0), (200, 0), (210, 0), (220, 0), (230, 0), (240, 0), (250, 0), (260, 0), (270, 0), (280, 0), (290, 0), (300, 0), (310, 0), (320, 0), (330, 0), (340, 0), (350, 0), (360, 0), (370, 0), (380, 0), (390, 0), (400, 0), (410, 0), (420, 0), (430, 0), (440, 0), (450, 0), (460, 0), (470, 0), (480, 0), (490, 0), (500, 0), (510, 0), (520, 0), (530, 0), (540, 0), (550, 0), (560, 0), (570, 0), (580, 0), (590, 0), (600, 0), (610, 0), (620, 0), (630, 0), (640, 0), (650, 0), (660, 0), (670, 0), (680, 0), (690, 0), (700, 0), (710, 0), (720, 0), (730, 0), (740, 0), (750, 0), (760, 0), (770, 0), (780, 0), (790, 0), (800, 0), (810, 0), (820, 0), (830, 0), (840, 0), (850, 0), (860, 0), (870, 0), (880, 0), (890, 0), (900, 0), (910, 0), (920, 0), (930, 0), (940, 0), (950, 0), (960, 0), (970, 0), (980, 0), (990, 0), (1000, 0), (1010, 0), (1020, 0), (1030, 0), (1040, 0), (1050, 0), (1060, 0), (1070, 0), (1080, 0), (1090, 0), (1100, 0), (1110, 0), (1120, 0), (1130, 0), (1140, 0), (1150, 0), (1160, 0), (1170, 0), (1180, 0), (1190, 0), (1200, 0), (1210, 0), (1220, 0), (1230, 0), (1240, 0), (1250, 0), (1260, 0), (1270, 0), (1280, 0), (1290, 0), (1300, 0), (1310, 0), (1320, 0), (1330, 0), (1340, 0), (1350, 0), (1360, 0), (1370, 0), (1380, 0), (1390, 0), (1400, 0), (1410, 0), (1420, 0), (1430, 0), (1440, 0), (1450, 0), (1460, 0), (1470, 0), (1480, 0), (1490, 0), (1500, 0), (1510, 0), (1520, 0), (1530, 0), (1540, 0), (1550, 0), (1560, 0), (1570, 0), (1580, 0), (1590, 0), (1600, 0), (1610, 0), (1620, 0), (1630, 0), (1640, 0), (1650, 0), (1660, 0), (1670, 0), (1680, 0), (1690, 0), (1700, 0), (1710, 0), (1720, 0), (1730, 0), (1740, 0), (1750, 0), (1760, 0), (1770, 0), (1780, 0), (1790, 0), (1800, 0), (1810, 0), (1820, 0), (1830, 0), (1840, 0), (1850, 0), (1860, 0), (1870, 0), (1880, 0), (1890, 0), (1900, 0), (1910, 0), (1920, 0), (1930, 0), (1940, 0), (1950, 0), (1960, 0), (1970, 0), (1980, 0), (1990, 0), (2000, 0), (2010, 0), (2020, 0), (2030, 0), (2040, 0), (2050, 0)]
Va0_0  a0_0  0 PWL (0n 0.0v 9.45n 0.0v 9.55n 0.0v 19.45n 0.0v 19.55n 0.0v 29.45n 0.0v 29.55n 0.0v 39.45n 0.0v 39.55n 0.0v 49.45n 0.0v 49.55n 0.0v 59.45n 0.0v 59.55n 0.0v 69.45n 0.0v 69.55n 0.0v 79.45n 0.0v 79.55n 0.0v 89.45n 0.0v 89.55n 0.0v 99.45n 0.0v 99.55n 0.0v 109.45n 0.0v 109.55n 0.0v 119.45n 0.0v 119.55n 0.0v 129.45n 0.0v 129.55n 0.0v 139.45n 0.0v 139.55n 0.0v 149.45n 0.0v 149.55n 0.0v 159.45n 0.0v 159.55n 0.0v 169.45n 0.0v 169.55n 0.0v 179.45n 0.0v 179.55n 0.0v 189.45n 0.0v 189.55n 0.0v 199.45n 0.0v 199.55n 0.0v 209.45n 0.0v 209.55n 0.0v 219.45n 0.0v 219.55n 0.0v 229.45n 0.0v 229.55n 0.0v 239.45n 0.0v 239.55n 0.0v 249.45n 0.0v 249.55n 0.0v 259.45n 0.0v 259.55n 0.0v 269.45n 0.0v 269.55n 0.0v 279.45n 0.0v 279.55n 0.0v 289.45n 0.0v 289.55n 0.0v 299.45n 0.0v 299.55n 0.0v 309.45n 0.0v 309.55n 0.0v 319.45n 0.0v 319.55n 0.0v 329.45n 0.0v 329.55n 0.0v 339.45n 0.0v 339.55n 0.0v 349.45n 0.0v 349.55n 0.0v 359.45n 0.0v 359.55n 0.0v 369.45n 0.0v 369.55n 0.0v 379.45n 0.0v 379.55n 0.0v 389.45n 0.0v 389.55n 0.0v 399.45n 0.0v 399.55n 0.0v 409.45n 0.0v 409.55n 0.0v 419.45n 0.0v 419.55n 0.0v 429.45n 0.0v 429.55n 0.0v 439.45n 0.0v 439.55n 0.0v 449.45n 0.0v 449.55n 0.0v 459.45n 0.0v 459.55n 0.0v 469.45n 0.0v 469.55n 0.0v 479.45n 0.0v 479.55n 0.0v 489.45n 0.0v 489.55n 0.0v 499.45n 0.0v 499.55n 0.0v 509.45n 0.0v 509.55n 0.0v 519.45n 0.0v 519.55n 0.0v 529.45n 0.0v 529.55n 0.0v 539.45n 0.0v 539.55n 0.0v 549.45n 0.0v 549.55n 0.0v 559.45n 0.0v 559.55n 0.0v 569.45n 0.0v 569.55n 0.0v 579.45n 0.0v 579.55n 0.0v 589.45n 0.0v 589.55n 0.0v 599.45n 0.0v 599.55n 0.0v 609.45n 0.0v 609.55n 0.0v 619.45n 0.0v 619.55n 0.0v 629.45n 0.0v 629.55n 0.0v 639.45n 0.0v 639.55n 0.0v 649.45n 0.0v 649.55n 0.0v 659.45n 0.0v 659.55n 0.0v 669.45n 0.0v 669.55n 0.0v 679.45n 0.0v 679.55n 0.0v 689.45n 0.0v 689.55n 0.0v 699.45n 0.0v 699.55n 0.0v 709.45n 0.0v 709.55n 0.0v 719.45n 0.0v 719.55n 0.0v 729.45n 0.0v 729.55n 0.0v 739.45n 0.0v 739.55n 0.0v 749.45n 0.0v 749.55n 0.0v 759.45n 0.0v 759.55n 0.0v 769.45n 0.0v 769.55n 0.0v 779.45n 0.0v 779.55n 0.0v 789.45n 0.0v 789.55n 0.0v 799.45n 0.0v 799.55n 0.0v 809.45n 0.0v 809.55n 0.0v 819.45n 0.0v 819.55n 0.0v 829.45n 0.0v 829.55n 0.0v 839.45n 0.0v 839.55n 0.0v 849.45n 0.0v 849.55n 0.0v 859.45n 0.0v 859.55n 0.0v 869.45n 0.0v 869.55n 0.0v 879.45n 0.0v 879.55n 0.0v 889.45n 0.0v 889.55n 0.0v 899.45n 0.0v 899.55n 0.0v 909.45n 0.0v 909.55n 0.0v 919.45n 0.0v 919.55n 0.0v 929.45n 0.0v 929.55n 0.0v 939.45n 0.0v 939.55n 0.0v 949.45n 0.0v 949.55n 0.0v 959.45n 0.0v 959.55n 0.0v 969.45n 0.0v 969.55n 0.0v 979.45n 0.0v 979.55n 0.0v 989.45n 0.0v 989.55n 0.0v 999.45n 0.0v 999.55n 0.0v 1009.45n 0.0v 1009.55n 0.0v 1019.45n 0.0v 1019.55n 0.0v 1029.45n 0.0v 1029.55n 0.0v 1039.45n 0.0v 1039.55n 0.0v 1049.45n 0.0v 1049.55n 0.0v 1059.45n 0.0v 1059.55n 0.0v 1069.45n 0.0v 1069.55n 0.0v 1079.45n 0.0v 1079.55n 0.0v 1089.45n 0.0v 1089.55n 0.0v 1099.45n 0.0v 1099.55n 0.0v 1109.45n 0.0v 1109.55n 0.0v 1119.45n 0.0v 1119.55n 0.0v 1129.45n 0.0v 1129.55n 0.0v 1139.45n 0.0v 1139.55n 0.0v 1149.45n 0.0v 1149.55n 0.0v 1159.45n 0.0v 1159.55n 0.0v 1169.45n 0.0v 1169.55n 0.0v 1179.45n 0.0v 1179.55n 0.0v 1189.45n 0.0v 1189.55n 0.0v 1199.45n 0.0v 1199.55n 0.0v 1209.45n 0.0v 1209.55n 0.0v 1219.45n 0.0v 1219.55n 0.0v 1229.45n 0.0v 1229.55n 0.0v 1239.45n 0.0v 1239.55n 0.0v 1249.45n 0.0v 1249.55n 0.0v 1259.45n 0.0v 1259.55n 0.0v 1269.45n 0.0v 1269.55n 0.0v 1279.45n 0.0v 1279.55n 0.0v 1289.45n 0.0v 1289.55n 0.0v 1299.45n 0.0v 1299.55n 0.0v 1309.45n 0.0v 1309.55n 0.0v 1319.45n 0.0v 1319.55n 0.0v 1329.45n 0.0v 1329.55n 0.0v 1339.45n 0.0v 1339.55n 0.0v 1349.45n 0.0v 1349.55n 0.0v 1359.45n 0.0v 1359.55n 0.0v 1369.45n 0.0v 1369.55n 0.0v 1379.45n 0.0v 1379.55n 0.0v 1389.45n 0.0v 1389.55n 0.0v 1399.45n 0.0v 1399.55n 0.0v 1409.45n 0.0v 1409.55n 0.0v 1419.45n 0.0v 1419.55n 0.0v 1429.45n 0.0v 1429.55n 0.0v 1439.45n 0.0v 1439.55n 0.0v 1449.45n 0.0v 1449.55n 0.0v 1459.45n 0.0v 1459.55n 0.0v 1469.45n 0.0v 1469.55n 0.0v 1479.45n 0.0v 1479.55n 0.0v 1489.45n 0.0v 1489.55n 0.0v 1499.45n 0.0v 1499.55n 0.0v 1509.45n 0.0v 1509.55n 0.0v 1519.45n 0.0v 1519.55n 0.0v 1529.45n 0.0v 1529.55n 0.0v 1539.45n 0.0v 1539.55n 0.0v 1549.45n 0.0v 1549.55n 0.0v 1559.45n 0.0v 1559.55n 0.0v 1569.45n 0.0v 1569.55n 0.0v 1579.45n 0.0v 1579.55n 0.0v 1589.45n 0.0v 1589.55n 0.0v 1599.45n 0.0v 1599.55n 0.0v 1609.45n 0.0v 1609.55n 0.0v 1619.45n 0.0v 1619.55n 0.0v 1629.45n 0.0v 1629.55n 0.0v 1639.45n 0.0v 1639.55n 0.0v 1649.45n 0.0v 1649.55n 0.0v 1659.45n 0.0v 1659.55n 0.0v 1669.45n 0.0v 1669.55n 0.0v 1679.45n 0.0v 1679.55n 0.0v 1689.45n 0.0v 1689.55n 0.0v 1699.45n 0.0v 1699.55n 0.0v 1709.45n 0.0v 1709.55n 0.0v 1719.45n 0.0v 1719.55n 0.0v 1729.45n 0.0v 1729.55n 0.0v 1739.45n 0.0v 1739.55n 0.0v 1749.45n 0.0v 1749.55n 0.0v 1759.45n 0.0v 1759.55n 0.0v 1769.45n 0.0v 1769.55n 0.0v 1779.45n 0.0v 1779.55n 0.0v 1789.45n 0.0v 1789.55n 0.0v 1799.45n 0.0v 1799.55n 0.0v 1809.45n 0.0v 1809.55n 0.0v 1819.45n 0.0v 1819.55n 0.0v 1829.45n 0.0v 1829.55n 0.0v 1839.45n 0.0v 1839.55n 0.0v 1849.45n 0.0v 1849.55n 0.0v 1859.45n 0.0v 1859.55n 0.0v 1869.45n 0.0v 1869.55n 0.0v 1879.45n 0.0v 1879.55n 0.0v 1889.45n 0.0v 1889.55n 0.0v 1899.45n 0.0v 1899.55n 0.0v 1909.45n 0.0v 1909.55n 0.0v 1919.45n 0.0v 1919.55n 0.0v 1929.45n 0.0v 1929.55n 0.0v 1939.45n 0.0v 1939.55n 0.0v 1949.45n 0.0v 1949.55n 0.0v 1959.45n 0.0v 1959.55n 0.0v 1969.45n 0.0v 1969.55n 0.0v 1979.45n 0.0v 1979.55n 0.0v 1989.45n 0.0v 1989.55n 0.0v 1999.45n 0.0v 1999.55n 0.0v 2009.45n 0.0v 2009.55n 0.0v 2019.45n 0.0v 2019.55n 0.0v 2029.45n 0.0v 2029.55n 0.0v 2039.45n 0.0v 2039.55n 0.0v 2049.45n 0.0v 2049.55n 0.0v )
* (time, data): [(0, 0), (10, 1), (20, 1), (30, 1), (40, 1), (50, 1), (60, 1), (70, 0), (80, 0), (90, 0), (100, 0), (110, 0), (120, 0), (130, 1), (140, 0), (150, 1), (160, 1), (170, 0), (180, 0), (190, 0), (200, 0), (210, 1), (220, 1), (230, 0), (240, 1), (250, 0), (260, 0), (270, 0), (280, 0), (290, 1), (300, 1), (310, 1), (320, 0), (330, 0), (340, 0), (350, 0), (360, 0), (370, 1), (380, 0), (390, 0), (400, 0), (410, 0), (420, 1), (430, 1), (440, 1), (450, 0), (460, 0), (470, 0), (480, 1), (490, 0), (500, 1), (510, 1), (520, 0), (530, 0), (540, 0), (550, 0), (560, 0), (570, 1), (580, 1), (590, 0), (600, 1), (610, 0), (620, 1), (630, 1), (640, 1), (650, 1), (660, 1), (670, 1), (680, 1), (690, 1), (700, 0), (710, 0), (720, 0), (730, 0), (740, 0), (750, 0), (760, 0), (770, 1), (780, 1), (790, 0), (800, 0), (810, 0), (820, 0), (830, 0), (840, 0), (850, 0), (860, 0), (870, 1), (880, 1), (890, 1), (900, 1), (910, 1), (920, 1), (930, 0), (940, 1), (950, 0), (960, 0), (970, 1), (980, 0), (990, 1), (1000, 0), (1010, 1), (1020, 1), (1030, 1), (1040, 1), (1050, 0), (1060, 1), (1070, 0), (1080, 0), (1090, 1), (1100, 0), (1110, 0), (1120, 1), (1130, 0), (1140, 0), (1150, 1), (1160, 1), (1170, 1), (1180, 0), (1190, 1), (1200, 1), (1210, 0), (1220, 0), (1230, 1), (1240, 1), (1250, 0), (1260, 1), (1270, 1), (1280, 1), (1290, 0), (1300, 0), (1310, 0), (1320, 0), (1330, 1), (1340, 1), (1350, 1), (1360, 1), (1370, 0), (1380, 0), (1390, 0), (1400, 1), (1410, 1), (1420, 0), (1430, 1), (1440, 0), (1450, 1), (1460, 1), (1470, 0), (1480, 1), (1490, 0), (1500, 1), (1510, 0), (1520, 0), (1530, 0), (1540, 0), (1550, 1), (1560, 0), (1570, 1), (1580, 1), (1590, 1), (1600, 1), (1610, 1), (1620, 1), (1630, 1), (1640, 1), (1650, 1), (1660, 0), (1670, 0), (1680, 1), (1690, 1), (1700, 1), (1710, 1), (1720, 1), (1730, 1), (1740, 1), (1750, 0), (1760, 1), (1770, 1), (1780, 1), (1790, 0), (1800, 1), (1810, 1), (1820, 1), (1830, 0), (1840, 1), (1850, 1), (1860, 0), (1870, 0), (1880, 0), (1890, 0), (1900, 0), (1910, 1), (1920, 1), (1930, 1), (1940, 0), (1950, 1), (1960, 1), (1970, 0), (1980, 0), (1990, 0), (2000, 0), (2010, 1), (2020, 1), (2030, 1), (2040, 1), (2050, 1)]
Va0_1  a0_1  0 PWL (0n 0.0v 9.45n 0.0v 9.55n 0.9v 19.45n 0.9v 19.55n 0.9v 29.45n 0.9v 29.55n 0.9v 39.45n 0.9v 39.55n 0.9v 49.45n 0.9v 49.55n 0.9v 59.45n 0.9v 59.55n 0.9v 69.45n 0.9v 69.55n 0.0v 79.45n 0.0v 79.55n 0.0v 89.45n 0.0v 89.55n 0.0v 99.45n 0.0v 99.55n 0.0v 109.45n 0.0v 109.55n 0.0v 119.45n 0.0v 119.55n 0.0v 129.45n 0.0v 129.55n 0.9v 139.45n 0.9v 139.55n 0.0v 149.45n 0.0v 149.55n 0.9v 159.45n 0.9v 159.55n 0.9v 169.45n 0.9v 169.55n 0.0v 179.45n 0.0v 179.55n 0.0v 189.45n 0.0v 189.55n 0.0v 199.45n 0.0v 199.55n 0.0v 209.45n 0.0v 209.55n 0.9v 219.45n 0.9v 219.55n 0.9v 229.45n 0.9v 229.55n 0.0v 239.45n 0.0v 239.55n 0.9v 249.45n 0.9v 249.55n 0.0v 259.45n 0.0v 259.55n 0.0v 269.45n 0.0v 269.55n 0.0v 279.45n 0.0v 279.55n 0.0v 289.45n 0.0v 289.55n 0.9v 299.45n 0.9v 299.55n 0.9v 309.45n 0.9v 309.55n 0.9v 319.45n 0.9v 319.55n 0.0v 329.45n 0.0v 329.55n 0.0v 339.45n 0.0v 339.55n 0.0v 349.45n 0.0v 349.55n 0.0v 359.45n 0.0v 359.55n 0.0v 369.45n 0.0v 369.55n 0.9v 379.45n 0.9v 379.55n 0.0v 389.45n 0.0v 389.55n 0.0v 399.45n 0.0v 399.55n 0.0v 409.45n 0.0v 409.55n 0.0v 419.45n 0.0v 419.55n 0.9v 429.45n 0.9v 429.55n 0.9v 439.45n 0.9v 439.55n 0.9v 449.45n 0.9v 449.55n 0.0v 459.45n 0.0v 459.55n 0.0v 469.45n 0.0v 469.55n 0.0v 479.45n 0.0v 479.55n 0.9v 489.45n 0.9v 489.55n 0.0v 499.45n 0.0v 499.55n 0.9v 509.45n 0.9v 509.55n 0.9v 519.45n 0.9v 519.55n 0.0v 529.45n 0.0v 529.55n 0.0v 539.45n 0.0v 539.55n 0.0v 549.45n 0.0v 549.55n 0.0v 559.45n 0.0v 559.55n 0.0v 569.45n 0.0v 569.55n 0.9v 579.45n 0.9v 579.55n 0.9v 589.45n 0.9v 589.55n 0.0v 599.45n 0.0v 599.55n 0.9v 609.45n 0.9v 609.55n 0.0v 619.45n 0.0v 619.55n 0.9v 629.45n 0.9v 629.55n 0.9v 639.45n 0.9v 639.55n 0.9v 649.45n 0.9v 649.55n 0.9v 659.45n 0.9v 659.55n 0.9v 669.45n 0.9v 669.55n 0.9v 679.45n 0.9v 679.55n 0.9v 689.45n 0.9v 689.55n 0.9v 699.45n 0.9v 699.55n 0.0v 709.45n 0.0v 709.55n 0.0v 719.45n 0.0v 719.55n 0.0v 729.45n 0.0v 729.55n 0.0v 739.45n 0.0v 739.55n 0.0v 749.45n 0.0v 749.55n 0.0v 759.45n 0.0v 759.55n 0.0v 769.45n 0.0v 769.55n 0.9v 779.45n 0.9v 779.55n 0.9v 789.45n 0.9v 789.55n 0.0v 799.45n 0.0v 799.55n 0.0v 809.45n 0.0v 809.55n 0.0v 819.45n 0.0v 819.55n 0.0v 829.45n 0.0v 829.55n 0.0v 839.45n 0.0v 839.55n 0.0v 849.45n 0.0v 849.55n 0.0v 859.45n 0.0v 859.55n 0.0v 869.45n 0.0v 869.55n 0.9v 879.45n 0.9v 879.55n 0.9v 889.45n 0.9v 889.55n 0.9v 899.45n 0.9v 899.55n 0.9v 909.45n 0.9v 909.55n 0.9v 919.45n 0.9v 919.55n 0.9v 929.45n 0.9v 929.55n 0.0v 939.45n 0.0v 939.55n 0.9v 949.45n 0.9v 949.55n 0.0v 959.45n 0.0v 959.55n 0.0v 969.45n 0.0v 969.55n 0.9v 979.45n 0.9v 979.55n 0.0v 989.45n 0.0v 989.55n 0.9v 999.45n 0.9v 999.55n 0.0v 1009.45n 0.0v 1009.55n 0.9v 1019.45n 0.9v 1019.55n 0.9v 1029.45n 0.9v 1029.55n 0.9v 1039.45n 0.9v 1039.55n 0.9v 1049.45n 0.9v 1049.55n 0.0v 1059.45n 0.0v 1059.55n 0.9v 1069.45n 0.9v 1069.55n 0.0v 1079.45n 0.0v 1079.55n 0.0v 1089.45n 0.0v 1089.55n 0.9v 1099.45n 0.9v 1099.55n 0.0v 1109.45n 0.0v 1109.55n 0.0v 1119.45n 0.0v 1119.55n 0.9v 1129.45n 0.9v 1129.55n 0.0v 1139.45n 0.0v 1139.55n 0.0v 1149.45n 0.0v 1149.55n 0.9v 1159.45n 0.9v 1159.55n 0.9v 1169.45n 0.9v 1169.55n 0.9v 1179.45n 0.9v 1179.55n 0.0v 1189.45n 0.0v 1189.55n 0.9v 1199.45n 0.9v 1199.55n 0.9v 1209.45n 0.9v 1209.55n 0.0v 1219.45n 0.0v 1219.55n 0.0v 1229.45n 0.0v 1229.55n 0.9v 1239.45n 0.9v 1239.55n 0.9v 1249.45n 0.9v 1249.55n 0.0v 1259.45n 0.0v 1259.55n 0.9v 1269.45n 0.9v 1269.55n 0.9v 1279.45n 0.9v 1279.55n 0.9v 1289.45n 0.9v 1289.55n 0.0v 1299.45n 0.0v 1299.55n 0.0v 1309.45n 0.0v 1309.55n 0.0v 1319.45n 0.0v 1319.55n 0.0v 1329.45n 0.0v 1329.55n 0.9v 1339.45n 0.9v 1339.55n 0.9v 1349.45n 0.9v 1349.55n 0.9v 1359.45n 0.9v 1359.55n 0.9v 1369.45n 0.9v 1369.55n 0.0v 1379.45n 0.0v 1379.55n 0.0v 1389.45n 0.0v 1389.55n 0.0v 1399.45n 0.0v 1399.55n 0.9v 1409.45n 0.9v 1409.55n 0.9v 1419.45n 0.9v 1419.55n 0.0v 1429.45n 0.0v 1429.55n 0.9v 1439.45n 0.9v 1439.55n 0.0v 1449.45n 0.0v 1449.55n 0.9v 1459.45n 0.9v 1459.55n 0.9v 1469.45n 0.9v 1469.55n 0.0v 1479.45n 0.0v 1479.55n 0.9v 1489.45n 0.9v 1489.55n 0.0v 1499.45n 0.0v 1499.55n 0.9v 1509.45n 0.9v 1509.55n 0.0v 1519.45n 0.0v 1519.55n 0.0v 1529.45n 0.0v 1529.55n 0.0v 1539.45n 0.0v 1539.55n 0.0v 1549.45n 0.0v 1549.55n 0.9v 1559.45n 0.9v 1559.55n 0.0v 1569.45n 0.0v 1569.55n 0.9v 1579.45n 0.9v 1579.55n 0.9v 1589.45n 0.9v 1589.55n 0.9v 1599.45n 0.9v 1599.55n 0.9v 1609.45n 0.9v 1609.55n 0.9v 1619.45n 0.9v 1619.55n 0.9v 1629.45n 0.9v 1629.55n 0.9v 1639.45n 0.9v 1639.55n 0.9v 1649.45n 0.9v 1649.55n 0.9v 1659.45n 0.9v 1659.55n 0.0v 1669.45n 0.0v 1669.55n 0.0v 1679.45n 0.0v 1679.55n 0.9v 1689.45n 0.9v 1689.55n 0.9v 1699.45n 0.9v 1699.55n 0.9v 1709.45n 0.9v 1709.55n 0.9v 1719.45n 0.9v 1719.55n 0.9v 1729.45n 0.9v 1729.55n 0.9v 1739.45n 0.9v 1739.55n 0.9v 1749.45n 0.9v 1749.55n 0.0v 1759.45n 0.0v 1759.55n 0.9v 1769.45n 0.9v 1769.55n 0.9v 1779.45n 0.9v 1779.55n 0.9v 1789.45n 0.9v 1789.55n 0.0v 1799.45n 0.0v 1799.55n 0.9v 1809.45n 0.9v 1809.55n 0.9v 1819.45n 0.9v 1819.55n 0.9v 1829.45n 0.9v 1829.55n 0.0v 1839.45n 0.0v 1839.55n 0.9v 1849.45n 0.9v 1849.55n 0.9v 1859.45n 0.9v 1859.55n 0.0v 1869.45n 0.0v 1869.55n 0.0v 1879.45n 0.0v 1879.55n 0.0v 1889.45n 0.0v 1889.55n 0.0v 1899.45n 0.0v 1899.55n 0.0v 1909.45n 0.0v 1909.55n 0.9v 1919.45n 0.9v 1919.55n 0.9v 1929.45n 0.9v 1929.55n 0.9v 1939.45n 0.9v 1939.55n 0.0v 1949.45n 0.0v 1949.55n 0.9v 1959.45n 0.9v 1959.55n 0.9v 1969.45n 0.9v 1969.55n 0.0v 1979.45n 0.0v 1979.55n 0.0v 1989.45n 0.0v 1989.55n 0.0v 1999.45n 0.0v 1999.55n 0.0v 2009.45n 0.0v 2009.55n 0.9v 2019.45n 0.9v 2019.55n 0.9v 2029.45n 0.9v 2029.55n 0.9v 2039.45n 0.9v 2039.55n 0.9v 2049.45n 0.9v 2049.55n 0.9v )
* (time, data): [(0, 0), (10, 1), (20, 1), (30, 1), (40, 1), (50, 1), (60, 1), (70, 0), (80, 0), (90, 0), (100, 0), (110, 0), (120, 0), (130, 1), (140, 0), (150, 1), (160, 1), (170, 0), (180, 0), (190, 0), (200, 0), (210, 1), (220, 1), (230, 0), (240, 1), (250, 0), (260, 0), (270, 0), (280, 0), (290, 1), (300, 1), (310, 1), (320, 0), (330, 0), (340, 0), (350, 0), (360, 0), (370, 1), (380, 0), (390, 0), (400, 0), (410, 0), (420, 1), (430, 1), (440, 1), (450, 0), (460, 0), (470, 0), (480, 1), (490, 0), (500, 1), (510, 1), (520, 0), (530, 0), (540, 0), (550, 0), (560, 0), (570, 1), (580, 1), (590, 0), (600, 1), (610, 0), (620, 1), (630, 1), (640, 1), (650, 1), (660, 1), (670, 1), (680, 1), (690, 1), (700, 0), (710, 0), (720, 0), (730, 0), (740, 0), (750, 0), (760, 0), (770, 1), (780, 1), (790, 0), (800, 0), (810, 0), (820, 0), (830, 0), (840, 0), (850, 0), (860, 0), (870, 1), (880, 1), (890, 1), (900, 1), (910, 1), (920, 1), (930, 0), (940, 1), (950, 0), (960, 0), (970, 1), (980, 0), (990, 1), (1000, 0), (1010, 1), (1020, 1), (1030, 1), (1040, 1), (1050, 0), (1060, 1), (1070, 0), (1080, 0), (1090, 1), (1100, 0), (1110, 0), (1120, 1), (1130, 0), (1140, 0), (1150, 1), (1160, 1), (1170, 1), (1180, 0), (1190, 1), (1200, 1), (1210, 0), (1220, 0), (1230, 1), (1240, 1), (1250, 0), (1260, 1), (1270, 1), (1280, 1), (1290, 0), (1300, 0), (1310, 0), (1320, 0), (1330, 1), (1340, 1), (1350, 1), (1360, 1), (1370, 0), (1380, 0), (1390, 0), (1400, 1), (1410, 1), (1420, 0), (1430, 1), (1440, 0), (1450, 1), (1460, 1), (1470, 0), (1480, 1), (1490, 0), (1500, 1), (1510, 0), (1520, 0), (1530, 0), (1540, 0), (1550, 1), (1560, 0), (1570, 1), (1580, 1), (1590, 1), (1600, 1), (1610, 1), (1620, 1), (1630, 1), (1640, 1), (1650, 1), (1660, 0), (1670, 0), (1680, 1), (1690, 1), (1700, 1), (1710, 1), (1720, 1), (1730, 1), (1740, 1), (1750, 0), (1760, 1), (1770, 1), (1780, 1), (1790, 0), (1800, 1), (1810, 1), (1820, 1), (1830, 0), (1840, 1), (1850, 1), (1860, 0), (1870, 0), (1880, 0), (1890, 0), (1900, 0), (1910, 1), (1920, 1), (1930, 1), (1940, 0), (1950, 1), (1960, 1), (1970, 0), (1980, 0), (1990, 0), (2000, 0), (2010, 1), (2020, 1), (2030, 1), (2040, 1), (2050, 1)]
Va0_2  a0_2  0 PWL (0n 0.0v 9.45n 0.0v 9.55n 0.9v 19.45n 0.9v 19.55n 0.9v 29.45n 0.9v 29.55n 0.9v 39.45n 0.9v 39.55n 0.9v 49.45n 0.9v 49.55n 0.9v 59.45n 0.9v 59.55n 0.9v 69.45n 0.9v 69.55n 0.0v 79.45n 0.0v 79.55n 0.0v 89.45n 0.0v 89.55n 0.0v 99.45n 0.0v 99.55n 0.0v 109.45n 0.0v 109.55n 0.0v 119.45n 0.0v 119.55n 0.0v 129.45n 0.0v 129.55n 0.9v 139.45n 0.9v 139.55n 0.0v 149.45n 0.0v 149.55n 0.9v 159.45n 0.9v 159.55n 0.9v 169.45n 0.9v 169.55n 0.0v 179.45n 0.0v 179.55n 0.0v 189.45n 0.0v 189.55n 0.0v 199.45n 0.0v 199.55n 0.0v 209.45n 0.0v 209.55n 0.9v 219.45n 0.9v 219.55n 0.9v 229.45n 0.9v 229.55n 0.0v 239.45n 0.0v 239.55n 0.9v 249.45n 0.9v 249.55n 0.0v 259.45n 0.0v 259.55n 0.0v 269.45n 0.0v 269.55n 0.0v 279.45n 0.0v 279.55n 0.0v 289.45n 0.0v 289.55n 0.9v 299.45n 0.9v 299.55n 0.9v 309.45n 0.9v 309.55n 0.9v 319.45n 0.9v 319.55n 0.0v 329.45n 0.0v 329.55n 0.0v 339.45n 0.0v 339.55n 0.0v 349.45n 0.0v 349.55n 0.0v 359.45n 0.0v 359.55n 0.0v 369.45n 0.0v 369.55n 0.9v 379.45n 0.9v 379.55n 0.0v 389.45n 0.0v 389.55n 0.0v 399.45n 0.0v 399.55n 0.0v 409.45n 0.0v 409.55n 0.0v 419.45n 0.0v 419.55n 0.9v 429.45n 0.9v 429.55n 0.9v 439.45n 0.9v 439.55n 0.9v 449.45n 0.9v 449.55n 0.0v 459.45n 0.0v 459.55n 0.0v 469.45n 0.0v 469.55n 0.0v 479.45n 0.0v 479.55n 0.9v 489.45n 0.9v 489.55n 0.0v 499.45n 0.0v 499.55n 0.9v 509.45n 0.9v 509.55n 0.9v 519.45n 0.9v 519.55n 0.0v 529.45n 0.0v 529.55n 0.0v 539.45n 0.0v 539.55n 0.0v 549.45n 0.0v 549.55n 0.0v 559.45n 0.0v 559.55n 0.0v 569.45n 0.0v 569.55n 0.9v 579.45n 0.9v 579.55n 0.9v 589.45n 0.9v 589.55n 0.0v 599.45n 0.0v 599.55n 0.9v 609.45n 0.9v 609.55n 0.0v 619.45n 0.0v 619.55n 0.9v 629.45n 0.9v 629.55n 0.9v 639.45n 0.9v 639.55n 0.9v 649.45n 0.9v 649.55n 0.9v 659.45n 0.9v 659.55n 0.9v 669.45n 0.9v 669.55n 0.9v 679.45n 0.9v 679.55n 0.9v 689.45n 0.9v 689.55n 0.9v 699.45n 0.9v 699.55n 0.0v 709.45n 0.0v 709.55n 0.0v 719.45n 0.0v 719.55n 0.0v 729.45n 0.0v 729.55n 0.0v 739.45n 0.0v 739.55n 0.0v 749.45n 0.0v 749.55n 0.0v 759.45n 0.0v 759.55n 0.0v 769.45n 0.0v 769.55n 0.9v 779.45n 0.9v 779.55n 0.9v 789.45n 0.9v 789.55n 0.0v 799.45n 0.0v 799.55n 0.0v 809.45n 0.0v 809.55n 0.0v 819.45n 0.0v 819.55n 0.0v 829.45n 0.0v 829.55n 0.0v 839.45n 0.0v 839.55n 0.0v 849.45n 0.0v 849.55n 0.0v 859.45n 0.0v 859.55n 0.0v 869.45n 0.0v 869.55n 0.9v 879.45n 0.9v 879.55n 0.9v 889.45n 0.9v 889.55n 0.9v 899.45n 0.9v 899.55n 0.9v 909.45n 0.9v 909.55n 0.9v 919.45n 0.9v 919.55n 0.9v 929.45n 0.9v 929.55n 0.0v 939.45n 0.0v 939.55n 0.9v 949.45n 0.9v 949.55n 0.0v 959.45n 0.0v 959.55n 0.0v 969.45n 0.0v 969.55n 0.9v 979.45n 0.9v 979.55n 0.0v 989.45n 0.0v 989.55n 0.9v 999.45n 0.9v 999.55n 0.0v 1009.45n 0.0v 1009.55n 0.9v 1019.45n 0.9v 1019.55n 0.9v 1029.45n 0.9v 1029.55n 0.9v 1039.45n 0.9v 1039.55n 0.9v 1049.45n 0.9v 1049.55n 0.0v 1059.45n 0.0v 1059.55n 0.9v 1069.45n 0.9v 1069.55n 0.0v 1079.45n 0.0v 1079.55n 0.0v 1089.45n 0.0v 1089.55n 0.9v 1099.45n 0.9v 1099.55n 0.0v 1109.45n 0.0v 1109.55n 0.0v 1119.45n 0.0v 1119.55n 0.9v 1129.45n 0.9v 1129.55n 0.0v 1139.45n 0.0v 1139.55n 0.0v 1149.45n 0.0v 1149.55n 0.9v 1159.45n 0.9v 1159.55n 0.9v 1169.45n 0.9v 1169.55n 0.9v 1179.45n 0.9v 1179.55n 0.0v 1189.45n 0.0v 1189.55n 0.9v 1199.45n 0.9v 1199.55n 0.9v 1209.45n 0.9v 1209.55n 0.0v 1219.45n 0.0v 1219.55n 0.0v 1229.45n 0.0v 1229.55n 0.9v 1239.45n 0.9v 1239.55n 0.9v 1249.45n 0.9v 1249.55n 0.0v 1259.45n 0.0v 1259.55n 0.9v 1269.45n 0.9v 1269.55n 0.9v 1279.45n 0.9v 1279.55n 0.9v 1289.45n 0.9v 1289.55n 0.0v 1299.45n 0.0v 1299.55n 0.0v 1309.45n 0.0v 1309.55n 0.0v 1319.45n 0.0v 1319.55n 0.0v 1329.45n 0.0v 1329.55n 0.9v 1339.45n 0.9v 1339.55n 0.9v 1349.45n 0.9v 1349.55n 0.9v 1359.45n 0.9v 1359.55n 0.9v 1369.45n 0.9v 1369.55n 0.0v 1379.45n 0.0v 1379.55n 0.0v 1389.45n 0.0v 1389.55n 0.0v 1399.45n 0.0v 1399.55n 0.9v 1409.45n 0.9v 1409.55n 0.9v 1419.45n 0.9v 1419.55n 0.0v 1429.45n 0.0v 1429.55n 0.9v 1439.45n 0.9v 1439.55n 0.0v 1449.45n 0.0v 1449.55n 0.9v 1459.45n 0.9v 1459.55n 0.9v 1469.45n 0.9v 1469.55n 0.0v 1479.45n 0.0v 1479.55n 0.9v 1489.45n 0.9v 1489.55n 0.0v 1499.45n 0.0v 1499.55n 0.9v 1509.45n 0.9v 1509.55n 0.0v 1519.45n 0.0v 1519.55n 0.0v 1529.45n 0.0v 1529.55n 0.0v 1539.45n 0.0v 1539.55n 0.0v 1549.45n 0.0v 1549.55n 0.9v 1559.45n 0.9v 1559.55n 0.0v 1569.45n 0.0v 1569.55n 0.9v 1579.45n 0.9v 1579.55n 0.9v 1589.45n 0.9v 1589.55n 0.9v 1599.45n 0.9v 1599.55n 0.9v 1609.45n 0.9v 1609.55n 0.9v 1619.45n 0.9v 1619.55n 0.9v 1629.45n 0.9v 1629.55n 0.9v 1639.45n 0.9v 1639.55n 0.9v 1649.45n 0.9v 1649.55n 0.9v 1659.45n 0.9v 1659.55n 0.0v 1669.45n 0.0v 1669.55n 0.0v 1679.45n 0.0v 1679.55n 0.9v 1689.45n 0.9v 1689.55n 0.9v 1699.45n 0.9v 1699.55n 0.9v 1709.45n 0.9v 1709.55n 0.9v 1719.45n 0.9v 1719.55n 0.9v 1729.45n 0.9v 1729.55n 0.9v 1739.45n 0.9v 1739.55n 0.9v 1749.45n 0.9v 1749.55n 0.0v 1759.45n 0.0v 1759.55n 0.9v 1769.45n 0.9v 1769.55n 0.9v 1779.45n 0.9v 1779.55n 0.9v 1789.45n 0.9v 1789.55n 0.0v 1799.45n 0.0v 1799.55n 0.9v 1809.45n 0.9v 1809.55n 0.9v 1819.45n 0.9v 1819.55n 0.9v 1829.45n 0.9v 1829.55n 0.0v 1839.45n 0.0v 1839.55n 0.9v 1849.45n 0.9v 1849.55n 0.9v 1859.45n 0.9v 1859.55n 0.0v 1869.45n 0.0v 1869.55n 0.0v 1879.45n 0.0v 1879.55n 0.0v 1889.45n 0.0v 1889.55n 0.0v 1899.45n 0.0v 1899.55n 0.0v 1909.45n 0.0v 1909.55n 0.9v 1919.45n 0.9v 1919.55n 0.9v 1929.45n 0.9v 1929.55n 0.9v 1939.45n 0.9v 1939.55n 0.0v 1949.45n 0.0v 1949.55n 0.9v 1959.45n 0.9v 1959.55n 0.9v 1969.45n 0.9v 1969.55n 0.0v 1979.45n 0.0v 1979.55n 0.0v 1989.45n 0.0v 1989.55n 0.0v 1999.45n 0.0v 1999.55n 0.0v 2009.45n 0.0v 2009.55n 0.9v 2019.45n 0.9v 2019.55n 0.9v 2029.45n 0.9v 2029.55n 0.9v 2039.45n 0.9v 2039.55n 0.9v 2049.45n 0.9v 2049.55n 0.9v )
* (time, data): [(0, 0), (10, 1), (20, 1), (30, 1), (40, 1), (50, 1), (60, 1), (70, 0), (80, 0), (90, 0), (100, 0), (110, 0), (120, 0), (130, 1), (140, 0), (150, 1), (160, 1), (170, 0), (180, 0), (190, 0), (200, 0), (210, 1), (220, 1), (230, 0), (240, 1), (250, 0), (260, 0), (270, 0), (280, 0), (290, 1), (300, 1), (310, 1), (320, 0), (330, 0), (340, 0), (350, 0), (360, 0), (370, 1), (380, 0), (390, 0), (400, 0), (410, 0), (420, 1), (430, 1), (440, 1), (450, 0), (460, 0), (470, 0), (480, 1), (490, 0), (500, 1), (510, 1), (520, 0), (530, 0), (540, 0), (550, 0), (560, 0), (570, 1), (580, 1), (590, 0), (600, 1), (610, 0), (620, 1), (630, 1), (640, 1), (650, 1), (660, 1), (670, 1), (680, 1), (690, 1), (700, 0), (710, 0), (720, 0), (730, 0), (740, 0), (750, 0), (760, 0), (770, 1), (780, 1), (790, 0), (800, 0), (810, 0), (820, 0), (830, 0), (840, 0), (850, 0), (860, 0), (870, 1), (880, 1), (890, 1), (900, 1), (910, 1), (920, 1), (930, 0), (940, 1), (950, 0), (960, 0), (970, 1), (980, 0), (990, 1), (1000, 0), (1010, 1), (1020, 1), (1030, 1), (1040, 1), (1050, 0), (1060, 1), (1070, 0), (1080, 0), (1090, 1), (1100, 0), (1110, 0), (1120, 1), (1130, 0), (1140, 0), (1150, 1), (1160, 1), (1170, 1), (1180, 0), (1190, 1), (1200, 1), (1210, 0), (1220, 0), (1230, 1), (1240, 1), (1250, 0), (1260, 1), (1270, 1), (1280, 1), (1290, 0), (1300, 0), (1310, 0), (1320, 0), (1330, 1), (1340, 1), (1350, 1), (1360, 1), (1370, 0), (1380, 0), (1390, 0), (1400, 1), (1410, 1), (1420, 0), (1430, 1), (1440, 0), (1450, 1), (1460, 1), (1470, 0), (1480, 1), (1490, 0), (1500, 1), (1510, 0), (1520, 0), (1530, 0), (1540, 0), (1550, 1), (1560, 0), (1570, 1), (1580, 1), (1590, 1), (1600, 1), (1610, 1), (1620, 1), (1630, 1), (1640, 1), (1650, 1), (1660, 0), (1670, 0), (1680, 1), (1690, 1), (1700, 1), (1710, 1), (1720, 1), (1730, 1), (1740, 1), (1750, 0), (1760, 1), (1770, 1), (1780, 1), (1790, 0), (1800, 1), (1810, 1), (1820, 1), (1830, 0), (1840, 1), (1850, 1), (1860, 0), (1870, 0), (1880, 0), (1890, 0), (1900, 0), (1910, 1), (1920, 1), (1930, 1), (1940, 0), (1950, 1), (1960, 1), (1970, 0), (1980, 0), (1990, 0), (2000, 0), (2010, 1), (2020, 1), (2030, 1), (2040, 1), (2050, 1)]
Va0_3  a0_3  0 PWL (0n 0.0v 9.45n 0.0v 9.55n 0.9v 19.45n 0.9v 19.55n 0.9v 29.45n 0.9v 29.55n 0.9v 39.45n 0.9v 39.55n 0.9v 49.45n 0.9v 49.55n 0.9v 59.45n 0.9v 59.55n 0.9v 69.45n 0.9v 69.55n 0.0v 79.45n 0.0v 79.55n 0.0v 89.45n 0.0v 89.55n 0.0v 99.45n 0.0v 99.55n 0.0v 109.45n 0.0v 109.55n 0.0v 119.45n 0.0v 119.55n 0.0v 129.45n 0.0v 129.55n 0.9v 139.45n 0.9v 139.55n 0.0v 149.45n 0.0v 149.55n 0.9v 159.45n 0.9v 159.55n 0.9v 169.45n 0.9v 169.55n 0.0v 179.45n 0.0v 179.55n 0.0v 189.45n 0.0v 189.55n 0.0v 199.45n 0.0v 199.55n 0.0v 209.45n 0.0v 209.55n 0.9v 219.45n 0.9v 219.55n 0.9v 229.45n 0.9v 229.55n 0.0v 239.45n 0.0v 239.55n 0.9v 249.45n 0.9v 249.55n 0.0v 259.45n 0.0v 259.55n 0.0v 269.45n 0.0v 269.55n 0.0v 279.45n 0.0v 279.55n 0.0v 289.45n 0.0v 289.55n 0.9v 299.45n 0.9v 299.55n 0.9v 309.45n 0.9v 309.55n 0.9v 319.45n 0.9v 319.55n 0.0v 329.45n 0.0v 329.55n 0.0v 339.45n 0.0v 339.55n 0.0v 349.45n 0.0v 349.55n 0.0v 359.45n 0.0v 359.55n 0.0v 369.45n 0.0v 369.55n 0.9v 379.45n 0.9v 379.55n 0.0v 389.45n 0.0v 389.55n 0.0v 399.45n 0.0v 399.55n 0.0v 409.45n 0.0v 409.55n 0.0v 419.45n 0.0v 419.55n 0.9v 429.45n 0.9v 429.55n 0.9v 439.45n 0.9v 439.55n 0.9v 449.45n 0.9v 449.55n 0.0v 459.45n 0.0v 459.55n 0.0v 469.45n 0.0v 469.55n 0.0v 479.45n 0.0v 479.55n 0.9v 489.45n 0.9v 489.55n 0.0v 499.45n 0.0v 499.55n 0.9v 509.45n 0.9v 509.55n 0.9v 519.45n 0.9v 519.55n 0.0v 529.45n 0.0v 529.55n 0.0v 539.45n 0.0v 539.55n 0.0v 549.45n 0.0v 549.55n 0.0v 559.45n 0.0v 559.55n 0.0v 569.45n 0.0v 569.55n 0.9v 579.45n 0.9v 579.55n 0.9v 589.45n 0.9v 589.55n 0.0v 599.45n 0.0v 599.55n 0.9v 609.45n 0.9v 609.55n 0.0v 619.45n 0.0v 619.55n 0.9v 629.45n 0.9v 629.55n 0.9v 639.45n 0.9v 639.55n 0.9v 649.45n 0.9v 649.55n 0.9v 659.45n 0.9v 659.55n 0.9v 669.45n 0.9v 669.55n 0.9v 679.45n 0.9v 679.55n 0.9v 689.45n 0.9v 689.55n 0.9v 699.45n 0.9v 699.55n 0.0v 709.45n 0.0v 709.55n 0.0v 719.45n 0.0v 719.55n 0.0v 729.45n 0.0v 729.55n 0.0v 739.45n 0.0v 739.55n 0.0v 749.45n 0.0v 749.55n 0.0v 759.45n 0.0v 759.55n 0.0v 769.45n 0.0v 769.55n 0.9v 779.45n 0.9v 779.55n 0.9v 789.45n 0.9v 789.55n 0.0v 799.45n 0.0v 799.55n 0.0v 809.45n 0.0v 809.55n 0.0v 819.45n 0.0v 819.55n 0.0v 829.45n 0.0v 829.55n 0.0v 839.45n 0.0v 839.55n 0.0v 849.45n 0.0v 849.55n 0.0v 859.45n 0.0v 859.55n 0.0v 869.45n 0.0v 869.55n 0.9v 879.45n 0.9v 879.55n 0.9v 889.45n 0.9v 889.55n 0.9v 899.45n 0.9v 899.55n 0.9v 909.45n 0.9v 909.55n 0.9v 919.45n 0.9v 919.55n 0.9v 929.45n 0.9v 929.55n 0.0v 939.45n 0.0v 939.55n 0.9v 949.45n 0.9v 949.55n 0.0v 959.45n 0.0v 959.55n 0.0v 969.45n 0.0v 969.55n 0.9v 979.45n 0.9v 979.55n 0.0v 989.45n 0.0v 989.55n 0.9v 999.45n 0.9v 999.55n 0.0v 1009.45n 0.0v 1009.55n 0.9v 1019.45n 0.9v 1019.55n 0.9v 1029.45n 0.9v 1029.55n 0.9v 1039.45n 0.9v 1039.55n 0.9v 1049.45n 0.9v 1049.55n 0.0v 1059.45n 0.0v 1059.55n 0.9v 1069.45n 0.9v 1069.55n 0.0v 1079.45n 0.0v 1079.55n 0.0v 1089.45n 0.0v 1089.55n 0.9v 1099.45n 0.9v 1099.55n 0.0v 1109.45n 0.0v 1109.55n 0.0v 1119.45n 0.0v 1119.55n 0.9v 1129.45n 0.9v 1129.55n 0.0v 1139.45n 0.0v 1139.55n 0.0v 1149.45n 0.0v 1149.55n 0.9v 1159.45n 0.9v 1159.55n 0.9v 1169.45n 0.9v 1169.55n 0.9v 1179.45n 0.9v 1179.55n 0.0v 1189.45n 0.0v 1189.55n 0.9v 1199.45n 0.9v 1199.55n 0.9v 1209.45n 0.9v 1209.55n 0.0v 1219.45n 0.0v 1219.55n 0.0v 1229.45n 0.0v 1229.55n 0.9v 1239.45n 0.9v 1239.55n 0.9v 1249.45n 0.9v 1249.55n 0.0v 1259.45n 0.0v 1259.55n 0.9v 1269.45n 0.9v 1269.55n 0.9v 1279.45n 0.9v 1279.55n 0.9v 1289.45n 0.9v 1289.55n 0.0v 1299.45n 0.0v 1299.55n 0.0v 1309.45n 0.0v 1309.55n 0.0v 1319.45n 0.0v 1319.55n 0.0v 1329.45n 0.0v 1329.55n 0.9v 1339.45n 0.9v 1339.55n 0.9v 1349.45n 0.9v 1349.55n 0.9v 1359.45n 0.9v 1359.55n 0.9v 1369.45n 0.9v 1369.55n 0.0v 1379.45n 0.0v 1379.55n 0.0v 1389.45n 0.0v 1389.55n 0.0v 1399.45n 0.0v 1399.55n 0.9v 1409.45n 0.9v 1409.55n 0.9v 1419.45n 0.9v 1419.55n 0.0v 1429.45n 0.0v 1429.55n 0.9v 1439.45n 0.9v 1439.55n 0.0v 1449.45n 0.0v 1449.55n 0.9v 1459.45n 0.9v 1459.55n 0.9v 1469.45n 0.9v 1469.55n 0.0v 1479.45n 0.0v 1479.55n 0.9v 1489.45n 0.9v 1489.55n 0.0v 1499.45n 0.0v 1499.55n 0.9v 1509.45n 0.9v 1509.55n 0.0v 1519.45n 0.0v 1519.55n 0.0v 1529.45n 0.0v 1529.55n 0.0v 1539.45n 0.0v 1539.55n 0.0v 1549.45n 0.0v 1549.55n 0.9v 1559.45n 0.9v 1559.55n 0.0v 1569.45n 0.0v 1569.55n 0.9v 1579.45n 0.9v 1579.55n 0.9v 1589.45n 0.9v 1589.55n 0.9v 1599.45n 0.9v 1599.55n 0.9v 1609.45n 0.9v 1609.55n 0.9v 1619.45n 0.9v 1619.55n 0.9v 1629.45n 0.9v 1629.55n 0.9v 1639.45n 0.9v 1639.55n 0.9v 1649.45n 0.9v 1649.55n 0.9v 1659.45n 0.9v 1659.55n 0.0v 1669.45n 0.0v 1669.55n 0.0v 1679.45n 0.0v 1679.55n 0.9v 1689.45n 0.9v 1689.55n 0.9v 1699.45n 0.9v 1699.55n 0.9v 1709.45n 0.9v 1709.55n 0.9v 1719.45n 0.9v 1719.55n 0.9v 1729.45n 0.9v 1729.55n 0.9v 1739.45n 0.9v 1739.55n 0.9v 1749.45n 0.9v 1749.55n 0.0v 1759.45n 0.0v 1759.55n 0.9v 1769.45n 0.9v 1769.55n 0.9v 1779.45n 0.9v 1779.55n 0.9v 1789.45n 0.9v 1789.55n 0.0v 1799.45n 0.0v 1799.55n 0.9v 1809.45n 0.9v 1809.55n 0.9v 1819.45n 0.9v 1819.55n 0.9v 1829.45n 0.9v 1829.55n 0.0v 1839.45n 0.0v 1839.55n 0.9v 1849.45n 0.9v 1849.55n 0.9v 1859.45n 0.9v 1859.55n 0.0v 1869.45n 0.0v 1869.55n 0.0v 1879.45n 0.0v 1879.55n 0.0v 1889.45n 0.0v 1889.55n 0.0v 1899.45n 0.0v 1899.55n 0.0v 1909.45n 0.0v 1909.55n 0.9v 1919.45n 0.9v 1919.55n 0.9v 1929.45n 0.9v 1929.55n 0.9v 1939.45n 0.9v 1939.55n 0.0v 1949.45n 0.0v 1949.55n 0.9v 1959.45n 0.9v 1959.55n 0.9v 1969.45n 0.9v 1969.55n 0.0v 1979.45n 0.0v 1979.55n 0.0v 1989.45n 0.0v 1989.55n 0.0v 1999.45n 0.0v 1999.55n 0.0v 2009.45n 0.0v 2009.55n 0.9v 2019.45n 0.9v 2019.55n 0.9v 2029.45n 0.9v 2029.55n 0.9v 2039.45n 0.9v 2039.55n 0.9v 2049.45n 0.9v 2049.55n 0.9v )

 * Generation of control signals
* (time, data): [(0, 1), (10, 0), (20, 0), (30, 0), (40, 0), (50, 1), (60, 0), (70, 0), (80, 0), (90, 0), (100, 1), (110, 0), (120, 1), (130, 0), (140, 0), (150, 0), (160, 0), (170, 0), (180, 0), (190, 1), (200, 0), (210, 0), (220, 0), (230, 0), (240, 0), (250, 0), (260, 0), (270, 1), (280, 1), (290, 0), (300, 0), (310, 1), (320, 0), (330, 0), (340, 1), (350, 0), (360, 1), (370, 0), (380, 0), (390, 0), (400, 0), (410, 1), (420, 0), (430, 0), (440, 0), (450, 0), (460, 1), (470, 0), (480, 0), (490, 0), (500, 0), (510, 1), (520, 0), (530, 1), (540, 0), (550, 1), (560, 1), (570, 0), (580, 0), (590, 0), (600, 0), (610, 0), (620, 0), (630, 1), (640, 0), (650, 1), (660, 0), (670, 1), (680, 1), (690, 1), (700, 0), (710, 0), (720, 0), (730, 1), (740, 0), (750, 0), (760, 1), (770, 0), (780, 0), (790, 0), (800, 0), (810, 0), (820, 0), (830, 0), (840, 1), (850, 1), (860, 0), (870, 0), (880, 1), (890, 0), (900, 0), (910, 0), (920, 1), (930, 0), (940, 0), (950, 0), (960, 0), (970, 0), (980, 0), (990, 0), (1000, 0), (1010, 0), (1020, 1), (1030, 1), (1040, 0), (1050, 0), (1060, 0), (1070, 0), (1080, 1), (1090, 0), (1100, 0), (1110, 0), (1120, 0), (1130, 0), (1140, 0), (1150, 0), (1160, 0), (1170, 1), (1180, 0), (1190, 0), (1200, 1), (1210, 0), (1220, 1), (1230, 0), (1240, 0), (1250, 0), (1260, 0), (1270, 1), (1280, 1), (1290, 0), (1300, 0), (1310, 0), (1320, 1), (1330, 0), (1340, 0), (1350, 0), (1360, 0), (1370, 0), (1380, 1), (1390, 0), (1400, 0), (1410, 1), (1420, 0), (1430, 0), (1440, 0), (1450, 0), (1460, 0), (1470, 0), (1480, 0), (1490, 0), (1500, 0), (1510, 0), (1520, 0), (1530, 1), (1540, 1), (1550, 0), (1560, 0), (1570, 0), (1580, 0), (1590, 0), (1600, 0), (1610, 1), (1620, 0), (1630, 0), (1640, 1), (1650, 0), (1660, 0), (1670, 1), (1680, 0), (1690, 0), (1700, 1), (1710, 0), (1720, 0), (1730, 1), (1740, 1), (1750, 0), (1760, 0), (1770, 0), (1780, 1), (1790, 0), (1800, 0), (1810, 1), (1820, 0), (1830, 0), (1840, 0), (1850, 0), (1860, 0), (1870, 0), (1880, 0), (1890, 0), (1900, 0), (1910, 0), (1920, 0), (1930, 1), (1940, 0), (1950, 0), (1960, 0), (1970, 0), (1980, 1), (1990, 0), (2000, 0), (2010, 0), (2020, 1), (2030, 0), (2040, 1), (2050, 1)]
VCSB0 CSB0 0 PWL (0n 0.9v 9.45n 0.9v 9.55n 0.0v 19.45n 0.0v 19.55n 0.0v 29.45n 0.0v 29.55n 0.0v 39.45n 0.0v 39.55n 0.0v 49.45n 0.0v 49.55n 0.9v 59.45n 0.9v 59.55n 0.0v 69.45n 0.0v 69.55n 0.0v 79.45n 0.0v 79.55n 0.0v 89.45n 0.0v 89.55n 0.0v 99.45n 0.0v 99.55n 0.9v 109.45n 0.9v 109.55n 0.0v 119.45n 0.0v 119.55n 0.9v 129.45n 0.9v 129.55n 0.0v 139.45n 0.0v 139.55n 0.0v 149.45n 0.0v 149.55n 0.0v 159.45n 0.0v 159.55n 0.0v 169.45n 0.0v 169.55n 0.0v 179.45n 0.0v 179.55n 0.0v 189.45n 0.0v 189.55n 0.9v 199.45n 0.9v 199.55n 0.0v 209.45n 0.0v 209.55n 0.0v 219.45n 0.0v 219.55n 0.0v 229.45n 0.0v 229.55n 0.0v 239.45n 0.0v 239.55n 0.0v 249.45n 0.0v 249.55n 0.0v 259.45n 0.0v 259.55n 0.0v 269.45n 0.0v 269.55n 0.9v 279.45n 0.9v 279.55n 0.9v 289.45n 0.9v 289.55n 0.0v 299.45n 0.0v 299.55n 0.0v 309.45n 0.0v 309.55n 0.9v 319.45n 0.9v 319.55n 0.0v 329.45n 0.0v 329.55n 0.0v 339.45n 0.0v 339.55n 0.9v 349.45n 0.9v 349.55n 0.0v 359.45n 0.0v 359.55n 0.9v 369.45n 0.9v 369.55n 0.0v 379.45n 0.0v 379.55n 0.0v 389.45n 0.0v 389.55n 0.0v 399.45n 0.0v 399.55n 0.0v 409.45n 0.0v 409.55n 0.9v 419.45n 0.9v 419.55n 0.0v 429.45n 0.0v 429.55n 0.0v 439.45n 0.0v 439.55n 0.0v 449.45n 0.0v 449.55n 0.0v 459.45n 0.0v 459.55n 0.9v 469.45n 0.9v 469.55n 0.0v 479.45n 0.0v 479.55n 0.0v 489.45n 0.0v 489.55n 0.0v 499.45n 0.0v 499.55n 0.0v 509.45n 0.0v 509.55n 0.9v 519.45n 0.9v 519.55n 0.0v 529.45n 0.0v 529.55n 0.9v 539.45n 0.9v 539.55n 0.0v 549.45n 0.0v 549.55n 0.9v 559.45n 0.9v 559.55n 0.9v 569.45n 0.9v 569.55n 0.0v 579.45n 0.0v 579.55n 0.0v 589.45n 0.0v 589.55n 0.0v 599.45n 0.0v 599.55n 0.0v 609.45n 0.0v 609.55n 0.0v 619.45n 0.0v 619.55n 0.0v 629.45n 0.0v 629.55n 0.9v 639.45n 0.9v 639.55n 0.0v 649.45n 0.0v 649.55n 0.9v 659.45n 0.9v 659.55n 0.0v 669.45n 0.0v 669.55n 0.9v 679.45n 0.9v 679.55n 0.9v 689.45n 0.9v 689.55n 0.9v 699.45n 0.9v 699.55n 0.0v 709.45n 0.0v 709.55n 0.0v 719.45n 0.0v 719.55n 0.0v 729.45n 0.0v 729.55n 0.9v 739.45n 0.9v 739.55n 0.0v 749.45n 0.0v 749.55n 0.0v 759.45n 0.0v 759.55n 0.9v 769.45n 0.9v 769.55n 0.0v 779.45n 0.0v 779.55n 0.0v 789.45n 0.0v 789.55n 0.0v 799.45n 0.0v 799.55n 0.0v 809.45n 0.0v 809.55n 0.0v 819.45n 0.0v 819.55n 0.0v 829.45n 0.0v 829.55n 0.0v 839.45n 0.0v 839.55n 0.9v 849.45n 0.9v 849.55n 0.9v 859.45n 0.9v 859.55n 0.0v 869.45n 0.0v 869.55n 0.0v 879.45n 0.0v 879.55n 0.9v 889.45n 0.9v 889.55n 0.0v 899.45n 0.0v 899.55n 0.0v 909.45n 0.0v 909.55n 0.0v 919.45n 0.0v 919.55n 0.9v 929.45n 0.9v 929.55n 0.0v 939.45n 0.0v 939.55n 0.0v 949.45n 0.0v 949.55n 0.0v 959.45n 0.0v 959.55n 0.0v 969.45n 0.0v 969.55n 0.0v 979.45n 0.0v 979.55n 0.0v 989.45n 0.0v 989.55n 0.0v 999.45n 0.0v 999.55n 0.0v 1009.45n 0.0v 1009.55n 0.0v 1019.45n 0.0v 1019.55n 0.9v 1029.45n 0.9v 1029.55n 0.9v 1039.45n 0.9v 1039.55n 0.0v 1049.45n 0.0v 1049.55n 0.0v 1059.45n 0.0v 1059.55n 0.0v 1069.45n 0.0v 1069.55n 0.0v 1079.45n 0.0v 1079.55n 0.9v 1089.45n 0.9v 1089.55n 0.0v 1099.45n 0.0v 1099.55n 0.0v 1109.45n 0.0v 1109.55n 0.0v 1119.45n 0.0v 1119.55n 0.0v 1129.45n 0.0v 1129.55n 0.0v 1139.45n 0.0v 1139.55n 0.0v 1149.45n 0.0v 1149.55n 0.0v 1159.45n 0.0v 1159.55n 0.0v 1169.45n 0.0v 1169.55n 0.9v 1179.45n 0.9v 1179.55n 0.0v 1189.45n 0.0v 1189.55n 0.0v 1199.45n 0.0v 1199.55n 0.9v 1209.45n 0.9v 1209.55n 0.0v 1219.45n 0.0v 1219.55n 0.9v 1229.45n 0.9v 1229.55n 0.0v 1239.45n 0.0v 1239.55n 0.0v 1249.45n 0.0v 1249.55n 0.0v 1259.45n 0.0v 1259.55n 0.0v 1269.45n 0.0v 1269.55n 0.9v 1279.45n 0.9v 1279.55n 0.9v 1289.45n 0.9v 1289.55n 0.0v 1299.45n 0.0v 1299.55n 0.0v 1309.45n 0.0v 1309.55n 0.0v 1319.45n 0.0v 1319.55n 0.9v 1329.45n 0.9v 1329.55n 0.0v 1339.45n 0.0v 1339.55n 0.0v 1349.45n 0.0v 1349.55n 0.0v 1359.45n 0.0v 1359.55n 0.0v 1369.45n 0.0v 1369.55n 0.0v 1379.45n 0.0v 1379.55n 0.9v 1389.45n 0.9v 1389.55n 0.0v 1399.45n 0.0v 1399.55n 0.0v 1409.45n 0.0v 1409.55n 0.9v 1419.45n 0.9v 1419.55n 0.0v 1429.45n 0.0v 1429.55n 0.0v 1439.45n 0.0v 1439.55n 0.0v 1449.45n 0.0v 1449.55n 0.0v 1459.45n 0.0v 1459.55n 0.0v 1469.45n 0.0v 1469.55n 0.0v 1479.45n 0.0v 1479.55n 0.0v 1489.45n 0.0v 1489.55n 0.0v 1499.45n 0.0v 1499.55n 0.0v 1509.45n 0.0v 1509.55n 0.0v 1519.45n 0.0v 1519.55n 0.0v 1529.45n 0.0v 1529.55n 0.9v 1539.45n 0.9v 1539.55n 0.9v 1549.45n 0.9v 1549.55n 0.0v 1559.45n 0.0v 1559.55n 0.0v 1569.45n 0.0v 1569.55n 0.0v 1579.45n 0.0v 1579.55n 0.0v 1589.45n 0.0v 1589.55n 0.0v 1599.45n 0.0v 1599.55n 0.0v 1609.45n 0.0v 1609.55n 0.9v 1619.45n 0.9v 1619.55n 0.0v 1629.45n 0.0v 1629.55n 0.0v 1639.45n 0.0v 1639.55n 0.9v 1649.45n 0.9v 1649.55n 0.0v 1659.45n 0.0v 1659.55n 0.0v 1669.45n 0.0v 1669.55n 0.9v 1679.45n 0.9v 1679.55n 0.0v 1689.45n 0.0v 1689.55n 0.0v 1699.45n 0.0v 1699.55n 0.9v 1709.45n 0.9v 1709.55n 0.0v 1719.45n 0.0v 1719.55n 0.0v 1729.45n 0.0v 1729.55n 0.9v 1739.45n 0.9v 1739.55n 0.9v 1749.45n 0.9v 1749.55n 0.0v 1759.45n 0.0v 1759.55n 0.0v 1769.45n 0.0v 1769.55n 0.0v 1779.45n 0.0v 1779.55n 0.9v 1789.45n 0.9v 1789.55n 0.0v 1799.45n 0.0v 1799.55n 0.0v 1809.45n 0.0v 1809.55n 0.9v 1819.45n 0.9v 1819.55n 0.0v 1829.45n 0.0v 1829.55n 0.0v 1839.45n 0.0v 1839.55n 0.0v 1849.45n 0.0v 1849.55n 0.0v 1859.45n 0.0v 1859.55n 0.0v 1869.45n 0.0v 1869.55n 0.0v 1879.45n 0.0v 1879.55n 0.0v 1889.45n 0.0v 1889.55n 0.0v 1899.45n 0.0v 1899.55n 0.0v 1909.45n 0.0v 1909.55n 0.0v 1919.45n 0.0v 1919.55n 0.0v 1929.45n 0.0v 1929.55n 0.9v 1939.45n 0.9v 1939.55n 0.0v 1949.45n 0.0v 1949.55n 0.0v 1959.45n 0.0v 1959.55n 0.0v 1969.45n 0.0v 1969.55n 0.0v 1979.45n 0.0v 1979.55n 0.9v 1989.45n 0.9v 1989.55n 0.0v 1999.45n 0.0v 1999.55n 0.0v 2009.45n 0.0v 2009.55n 0.0v 2019.45n 0.0v 2019.55n 0.9v 2029.45n 0.9v 2029.55n 0.0v 2039.45n 0.0v 2039.55n 0.9v 2049.45n 0.9v 2049.55n 0.9v )
* (time, data): [(0, 1), (10, 0), (20, 0), (30, 0), (40, 1), (50, 1), (60, 0), (70, 0), (80, 0), (90, 0), (100, 1), (110, 1), (120, 1), (130, 1), (140, 0), (150, 0), (160, 0), (170, 1), (180, 1), (190, 1), (200, 1), (210, 1), (220, 0), (230, 1), (240, 1), (250, 1), (260, 1), (270, 1), (280, 1), (290, 1), (300, 1), (310, 1), (320, 1), (330, 1), (340, 1), (350, 1), (360, 1), (370, 1), (380, 1), (390, 1), (400, 0), (410, 1), (420, 0), (430, 1), (440, 1), (450, 0), (460, 1), (470, 1), (480, 1), (490, 0), (500, 0), (510, 1), (520, 1), (530, 1), (540, 0), (550, 1), (560, 1), (570, 1), (580, 1), (590, 1), (600, 1), (610, 0), (620, 1), (630, 1), (640, 0), (650, 1), (660, 0), (670, 1), (680, 1), (690, 1), (700, 0), (710, 0), (720, 1), (730, 1), (740, 1), (750, 1), (760, 1), (770, 1), (780, 1), (790, 0), (800, 0), (810, 0), (820, 1), (830, 1), (840, 1), (850, 1), (860, 0), (870, 1), (880, 1), (890, 0), (900, 1), (910, 0), (920, 1), (930, 1), (940, 0), (950, 1), (960, 0), (970, 1), (980, 1), (990, 0), (1000, 0), (1010, 0), (1020, 1), (1030, 1), (1040, 1), (1050, 1), (1060, 0), (1070, 1), (1080, 1), (1090, 1), (1100, 1), (1110, 1), (1120, 1), (1130, 1), (1140, 1), (1150, 1), (1160, 1), (1170, 1), (1180, 1), (1190, 1), (1200, 1), (1210, 1), (1220, 1), (1230, 0), (1240, 0), (1250, 0), (1260, 1), (1270, 1), (1280, 1), (1290, 0), (1300, 0), (1310, 0), (1320, 1), (1330, 0), (1340, 1), (1350, 0), (1360, 1), (1370, 0), (1380, 1), (1390, 1), (1400, 1), (1410, 1), (1420, 1), (1430, 1), (1440, 1), (1450, 1), (1460, 0), (1470, 0), (1480, 1), (1490, 1), (1500, 1), (1510, 1), (1520, 1), (1530, 1), (1540, 1), (1550, 0), (1560, 1), (1570, 1), (1580, 1), (1590, 1), (1600, 1), (1610, 1), (1620, 0), (1630, 1), (1640, 1), (1650, 1), (1660, 1), (1670, 1), (1680, 1), (1690, 1), (1700, 1), (1710, 1), (1720, 0), (1730, 1), (1740, 1), (1750, 1), (1760, 1), (1770, 0), (1780, 1), (1790, 1), (1800, 1), (1810, 1), (1820, 1), (1830, 1), (1840, 1), (1850, 0), (1860, 1), (1870, 1), (1880, 1), (1890, 0), (1900, 1), (1910, 0), (1920, 0), (1930, 1), (1940, 0), (1950, 1), (1960, 1), (1970, 1), (1980, 1), (1990, 1), (2000, 1), (2010, 1), (2020, 1), (2030, 1), (2040, 1), (2050, 1)]
VWEB0 WEB0 0 PWL (0n 0.9v 9.45n 0.9v 9.55n 0.0v 19.45n 0.0v 19.55n 0.0v 29.45n 0.0v 29.55n 0.0v 39.45n 0.0v 39.55n 0.9v 49.45n 0.9v 49.55n 0.9v 59.45n 0.9v 59.55n 0.0v 69.45n 0.0v 69.55n 0.0v 79.45n 0.0v 79.55n 0.0v 89.45n 0.0v 89.55n 0.0v 99.45n 0.0v 99.55n 0.9v 109.45n 0.9v 109.55n 0.9v 119.45n 0.9v 119.55n 0.9v 129.45n 0.9v 129.55n 0.9v 139.45n 0.9v 139.55n 0.0v 149.45n 0.0v 149.55n 0.0v 159.45n 0.0v 159.55n 0.0v 169.45n 0.0v 169.55n 0.9v 179.45n 0.9v 179.55n 0.9v 189.45n 0.9v 189.55n 0.9v 199.45n 0.9v 199.55n 0.9v 209.45n 0.9v 209.55n 0.9v 219.45n 0.9v 219.55n 0.0v 229.45n 0.0v 229.55n 0.9v 239.45n 0.9v 239.55n 0.9v 249.45n 0.9v 249.55n 0.9v 259.45n 0.9v 259.55n 0.9v 269.45n 0.9v 269.55n 0.9v 279.45n 0.9v 279.55n 0.9v 289.45n 0.9v 289.55n 0.9v 299.45n 0.9v 299.55n 0.9v 309.45n 0.9v 309.55n 0.9v 319.45n 0.9v 319.55n 0.9v 329.45n 0.9v 329.55n 0.9v 339.45n 0.9v 339.55n 0.9v 349.45n 0.9v 349.55n 0.9v 359.45n 0.9v 359.55n 0.9v 369.45n 0.9v 369.55n 0.9v 379.45n 0.9v 379.55n 0.9v 389.45n 0.9v 389.55n 0.9v 399.45n 0.9v 399.55n 0.0v 409.45n 0.0v 409.55n 0.9v 419.45n 0.9v 419.55n 0.0v 429.45n 0.0v 429.55n 0.9v 439.45n 0.9v 439.55n 0.9v 449.45n 0.9v 449.55n 0.0v 459.45n 0.0v 459.55n 0.9v 469.45n 0.9v 469.55n 0.9v 479.45n 0.9v 479.55n 0.9v 489.45n 0.9v 489.55n 0.0v 499.45n 0.0v 499.55n 0.0v 509.45n 0.0v 509.55n 0.9v 519.45n 0.9v 519.55n 0.9v 529.45n 0.9v 529.55n 0.9v 539.45n 0.9v 539.55n 0.0v 549.45n 0.0v 549.55n 0.9v 559.45n 0.9v 559.55n 0.9v 569.45n 0.9v 569.55n 0.9v 579.45n 0.9v 579.55n 0.9v 589.45n 0.9v 589.55n 0.9v 599.45n 0.9v 599.55n 0.9v 609.45n 0.9v 609.55n 0.0v 619.45n 0.0v 619.55n 0.9v 629.45n 0.9v 629.55n 0.9v 639.45n 0.9v 639.55n 0.0v 649.45n 0.0v 649.55n 0.9v 659.45n 0.9v 659.55n 0.0v 669.45n 0.0v 669.55n 0.9v 679.45n 0.9v 679.55n 0.9v 689.45n 0.9v 689.55n 0.9v 699.45n 0.9v 699.55n 0.0v 709.45n 0.0v 709.55n 0.0v 719.45n 0.0v 719.55n 0.9v 729.45n 0.9v 729.55n 0.9v 739.45n 0.9v 739.55n 0.9v 749.45n 0.9v 749.55n 0.9v 759.45n 0.9v 759.55n 0.9v 769.45n 0.9v 769.55n 0.9v 779.45n 0.9v 779.55n 0.9v 789.45n 0.9v 789.55n 0.0v 799.45n 0.0v 799.55n 0.0v 809.45n 0.0v 809.55n 0.0v 819.45n 0.0v 819.55n 0.9v 829.45n 0.9v 829.55n 0.9v 839.45n 0.9v 839.55n 0.9v 849.45n 0.9v 849.55n 0.9v 859.45n 0.9v 859.55n 0.0v 869.45n 0.0v 869.55n 0.9v 879.45n 0.9v 879.55n 0.9v 889.45n 0.9v 889.55n 0.0v 899.45n 0.0v 899.55n 0.9v 909.45n 0.9v 909.55n 0.0v 919.45n 0.0v 919.55n 0.9v 929.45n 0.9v 929.55n 0.9v 939.45n 0.9v 939.55n 0.0v 949.45n 0.0v 949.55n 0.9v 959.45n 0.9v 959.55n 0.0v 969.45n 0.0v 969.55n 0.9v 979.45n 0.9v 979.55n 0.9v 989.45n 0.9v 989.55n 0.0v 999.45n 0.0v 999.55n 0.0v 1009.45n 0.0v 1009.55n 0.0v 1019.45n 0.0v 1019.55n 0.9v 1029.45n 0.9v 1029.55n 0.9v 1039.45n 0.9v 1039.55n 0.9v 1049.45n 0.9v 1049.55n 0.9v 1059.45n 0.9v 1059.55n 0.0v 1069.45n 0.0v 1069.55n 0.9v 1079.45n 0.9v 1079.55n 0.9v 1089.45n 0.9v 1089.55n 0.9v 1099.45n 0.9v 1099.55n 0.9v 1109.45n 0.9v 1109.55n 0.9v 1119.45n 0.9v 1119.55n 0.9v 1129.45n 0.9v 1129.55n 0.9v 1139.45n 0.9v 1139.55n 0.9v 1149.45n 0.9v 1149.55n 0.9v 1159.45n 0.9v 1159.55n 0.9v 1169.45n 0.9v 1169.55n 0.9v 1179.45n 0.9v 1179.55n 0.9v 1189.45n 0.9v 1189.55n 0.9v 1199.45n 0.9v 1199.55n 0.9v 1209.45n 0.9v 1209.55n 0.9v 1219.45n 0.9v 1219.55n 0.9v 1229.45n 0.9v 1229.55n 0.0v 1239.45n 0.0v 1239.55n 0.0v 1249.45n 0.0v 1249.55n 0.0v 1259.45n 0.0v 1259.55n 0.9v 1269.45n 0.9v 1269.55n 0.9v 1279.45n 0.9v 1279.55n 0.9v 1289.45n 0.9v 1289.55n 0.0v 1299.45n 0.0v 1299.55n 0.0v 1309.45n 0.0v 1309.55n 0.0v 1319.45n 0.0v 1319.55n 0.9v 1329.45n 0.9v 1329.55n 0.0v 1339.45n 0.0v 1339.55n 0.9v 1349.45n 0.9v 1349.55n 0.0v 1359.45n 0.0v 1359.55n 0.9v 1369.45n 0.9v 1369.55n 0.0v 1379.45n 0.0v 1379.55n 0.9v 1389.45n 0.9v 1389.55n 0.9v 1399.45n 0.9v 1399.55n 0.9v 1409.45n 0.9v 1409.55n 0.9v 1419.45n 0.9v 1419.55n 0.9v 1429.45n 0.9v 1429.55n 0.9v 1439.45n 0.9v 1439.55n 0.9v 1449.45n 0.9v 1449.55n 0.9v 1459.45n 0.9v 1459.55n 0.0v 1469.45n 0.0v 1469.55n 0.0v 1479.45n 0.0v 1479.55n 0.9v 1489.45n 0.9v 1489.55n 0.9v 1499.45n 0.9v 1499.55n 0.9v 1509.45n 0.9v 1509.55n 0.9v 1519.45n 0.9v 1519.55n 0.9v 1529.45n 0.9v 1529.55n 0.9v 1539.45n 0.9v 1539.55n 0.9v 1549.45n 0.9v 1549.55n 0.0v 1559.45n 0.0v 1559.55n 0.9v 1569.45n 0.9v 1569.55n 0.9v 1579.45n 0.9v 1579.55n 0.9v 1589.45n 0.9v 1589.55n 0.9v 1599.45n 0.9v 1599.55n 0.9v 1609.45n 0.9v 1609.55n 0.9v 1619.45n 0.9v 1619.55n 0.0v 1629.45n 0.0v 1629.55n 0.9v 1639.45n 0.9v 1639.55n 0.9v 1649.45n 0.9v 1649.55n 0.9v 1659.45n 0.9v 1659.55n 0.9v 1669.45n 0.9v 1669.55n 0.9v 1679.45n 0.9v 1679.55n 0.9v 1689.45n 0.9v 1689.55n 0.9v 1699.45n 0.9v 1699.55n 0.9v 1709.45n 0.9v 1709.55n 0.9v 1719.45n 0.9v 1719.55n 0.0v 1729.45n 0.0v 1729.55n 0.9v 1739.45n 0.9v 1739.55n 0.9v 1749.45n 0.9v 1749.55n 0.9v 1759.45n 0.9v 1759.55n 0.9v 1769.45n 0.9v 1769.55n 0.0v 1779.45n 0.0v 1779.55n 0.9v 1789.45n 0.9v 1789.55n 0.9v 1799.45n 0.9v 1799.55n 0.9v 1809.45n 0.9v 1809.55n 0.9v 1819.45n 0.9v 1819.55n 0.9v 1829.45n 0.9v 1829.55n 0.9v 1839.45n 0.9v 1839.55n 0.9v 1849.45n 0.9v 1849.55n 0.0v 1859.45n 0.0v 1859.55n 0.9v 1869.45n 0.9v 1869.55n 0.9v 1879.45n 0.9v 1879.55n 0.9v 1889.45n 0.9v 1889.55n 0.0v 1899.45n 0.0v 1899.55n 0.9v 1909.45n 0.9v 1909.55n 0.0v 1919.45n 0.0v 1919.55n 0.0v 1929.45n 0.0v 1929.55n 0.9v 1939.45n 0.9v 1939.55n 0.0v 1949.45n 0.0v 1949.55n 0.9v 1959.45n 0.9v 1959.55n 0.9v 1969.45n 0.9v 1969.55n 0.9v 1979.45n 0.9v 1979.55n 0.9v 1989.45n 0.9v 1989.55n 0.9v 1999.45n 0.9v 1999.55n 0.9v 2009.45n 0.9v 2009.55n 0.9v 2019.45n 0.9v 2019.55n 0.9v 2029.45n 0.9v 2029.55n 0.9v 2039.45n 0.9v 2039.55n 0.9v 2049.45n 0.9v 2049.55n 0.9v )
* PULSE: period=10
Vclk0 clk0 0 PULSE (0 0.9 9.95n 0.1n 0.1n 4.9n 10n)

 * Generation of dout measurements
* CHECK dout0_0 vdout0_0ck4 = 0 time = 50
* CHECK dout0_1 vdout0_1ck4 = 0 time = 50
* CHECK dout0_2 vdout0_2ck4 = 0.9 time = 50
* CHECK dout0_3 vdout0_3ck4 = 0 time = 50
* CHECK dout0_4 vdout0_4ck4 = 0 time = 50
* CHECK dout0_5 vdout0_5ck4 = 0 time = 50
* CHECK dout0_6 vdout0_6ck4 = 0 time = 50
* CHECK dout0_7 vdout0_7ck4 = 0 time = 50
* CHECK dout0_0 vdout0_0ck11 = 0 time = 120
* CHECK dout0_1 vdout0_1ck11 = 0.9 time = 120
* CHECK dout0_2 vdout0_2ck11 = 0.9 time = 120
* CHECK dout0_3 vdout0_3ck11 = 0 time = 120
* CHECK dout0_4 vdout0_4ck11 = 0.9 time = 120
* CHECK dout0_5 vdout0_5ck11 = 0.9 time = 120
* CHECK dout0_6 vdout0_6ck11 = 0 time = 120
* CHECK dout0_7 vdout0_7ck11 = 0 time = 120
* CHECK dout0_0 vdout0_0ck13 = 0.9 time = 140
* CHECK dout0_1 vdout0_1ck13 = 0 time = 140
* CHECK dout0_2 vdout0_2ck13 = 0 time = 140
* CHECK dout0_3 vdout0_3ck13 = 0 time = 140
* CHECK dout0_4 vdout0_4ck13 = 0.9 time = 140
* CHECK dout0_5 vdout0_5ck13 = 0.9 time = 140
* CHECK dout0_6 vdout0_6ck13 = 0.9 time = 140
* CHECK dout0_7 vdout0_7ck13 = 0 time = 140
* CHECK dout0_0 vdout0_0ck17 = 0 time = 180
* CHECK dout0_1 vdout0_1ck17 = 0 time = 180
* CHECK dout0_2 vdout0_2ck17 = 0.9 time = 180
* CHECK dout0_3 vdout0_3ck17 = 0.9 time = 180
* CHECK dout0_4 vdout0_4ck17 = 0 time = 180
* CHECK dout0_5 vdout0_5ck17 = 0.9 time = 180
* CHECK dout0_6 vdout0_6ck17 = 0 time = 180
* CHECK dout0_7 vdout0_7ck17 = 0 time = 180
* CHECK dout0_0 vdout0_0ck18 = 0 time = 190
* CHECK dout0_1 vdout0_1ck18 = 0 time = 190
* CHECK dout0_2 vdout0_2ck18 = 0.9 time = 190
* CHECK dout0_3 vdout0_3ck18 = 0.9 time = 190
* CHECK dout0_4 vdout0_4ck18 = 0 time = 190
* CHECK dout0_5 vdout0_5ck18 = 0.9 time = 190
* CHECK dout0_6 vdout0_6ck18 = 0 time = 190
* CHECK dout0_7 vdout0_7ck18 = 0 time = 190
* CHECK dout0_0 vdout0_0ck20 = 0 time = 210
* CHECK dout0_1 vdout0_1ck20 = 0 time = 210
* CHECK dout0_2 vdout0_2ck20 = 0.9 time = 210
* CHECK dout0_3 vdout0_3ck20 = 0.9 time = 210
* CHECK dout0_4 vdout0_4ck20 = 0 time = 210
* CHECK dout0_5 vdout0_5ck20 = 0.9 time = 210
* CHECK dout0_6 vdout0_6ck20 = 0 time = 210
* CHECK dout0_7 vdout0_7ck20 = 0 time = 210
* CHECK dout0_0 vdout0_0ck21 = 0.9 time = 220
* CHECK dout0_1 vdout0_1ck21 = 0.9 time = 220
* CHECK dout0_2 vdout0_2ck21 = 0 time = 220
* CHECK dout0_3 vdout0_3ck21 = 0 time = 220
* CHECK dout0_4 vdout0_4ck21 = 0.9 time = 220
* CHECK dout0_5 vdout0_5ck21 = 0 time = 220
* CHECK dout0_6 vdout0_6ck21 = 0.9 time = 220
* CHECK dout0_7 vdout0_7ck21 = 0.9 time = 220
* CHECK dout0_0 vdout0_0ck23 = 0 time = 240
* CHECK dout0_1 vdout0_1ck23 = 0 time = 240
* CHECK dout0_2 vdout0_2ck23 = 0.9 time = 240
* CHECK dout0_3 vdout0_3ck23 = 0.9 time = 240
* CHECK dout0_4 vdout0_4ck23 = 0 time = 240
* CHECK dout0_5 vdout0_5ck23 = 0.9 time = 240
* CHECK dout0_6 vdout0_6ck23 = 0 time = 240
* CHECK dout0_7 vdout0_7ck23 = 0 time = 240
* CHECK dout0_0 vdout0_0ck24 = 0.9 time = 250
* CHECK dout0_1 vdout0_1ck24 = 0.9 time = 250
* CHECK dout0_2 vdout0_2ck24 = 0 time = 250
* CHECK dout0_3 vdout0_3ck24 = 0 time = 250
* CHECK dout0_4 vdout0_4ck24 = 0 time = 250
* CHECK dout0_5 vdout0_5ck24 = 0.9 time = 250
* CHECK dout0_6 vdout0_6ck24 = 0 time = 250
* CHECK dout0_7 vdout0_7ck24 = 0.9 time = 250
* CHECK dout0_0 vdout0_0ck25 = 0 time = 260
* CHECK dout0_1 vdout0_1ck25 = 0 time = 260
* CHECK dout0_2 vdout0_2ck25 = 0.9 time = 260
* CHECK dout0_3 vdout0_3ck25 = 0.9 time = 260
* CHECK dout0_4 vdout0_4ck25 = 0 time = 260
* CHECK dout0_5 vdout0_5ck25 = 0.9 time = 260
* CHECK dout0_6 vdout0_6ck25 = 0 time = 260
* CHECK dout0_7 vdout0_7ck25 = 0 time = 260
* CHECK dout0_0 vdout0_0ck26 = 0 time = 270
* CHECK dout0_1 vdout0_1ck26 = 0 time = 270
* CHECK dout0_2 vdout0_2ck26 = 0.9 time = 270
* CHECK dout0_3 vdout0_3ck26 = 0.9 time = 270
* CHECK dout0_4 vdout0_4ck26 = 0 time = 270
* CHECK dout0_5 vdout0_5ck26 = 0.9 time = 270
* CHECK dout0_6 vdout0_6ck26 = 0 time = 270
* CHECK dout0_7 vdout0_7ck26 = 0 time = 270
* CHECK dout0_0 vdout0_0ck29 = 0.9 time = 300
* CHECK dout0_1 vdout0_1ck29 = 0.9 time = 300
* CHECK dout0_2 vdout0_2ck29 = 0 time = 300
* CHECK dout0_3 vdout0_3ck29 = 0 time = 300
* CHECK dout0_4 vdout0_4ck29 = 0 time = 300
* CHECK dout0_5 vdout0_5ck29 = 0.9 time = 300
* CHECK dout0_6 vdout0_6ck29 = 0 time = 300
* CHECK dout0_7 vdout0_7ck29 = 0.9 time = 300
* CHECK dout0_0 vdout0_0ck30 = 0.9 time = 310
* CHECK dout0_1 vdout0_1ck30 = 0.9 time = 310
* CHECK dout0_2 vdout0_2ck30 = 0 time = 310
* CHECK dout0_3 vdout0_3ck30 = 0 time = 310
* CHECK dout0_4 vdout0_4ck30 = 0 time = 310
* CHECK dout0_5 vdout0_5ck30 = 0.9 time = 310
* CHECK dout0_6 vdout0_6ck30 = 0 time = 310
* CHECK dout0_7 vdout0_7ck30 = 0.9 time = 310
* CHECK dout0_0 vdout0_0ck32 = 0 time = 330
* CHECK dout0_1 vdout0_1ck32 = 0 time = 330
* CHECK dout0_2 vdout0_2ck32 = 0.9 time = 330
* CHECK dout0_3 vdout0_3ck32 = 0.9 time = 330
* CHECK dout0_4 vdout0_4ck32 = 0 time = 330
* CHECK dout0_5 vdout0_5ck32 = 0.9 time = 330
* CHECK dout0_6 vdout0_6ck32 = 0 time = 330
* CHECK dout0_7 vdout0_7ck32 = 0 time = 330
* CHECK dout0_0 vdout0_0ck33 = 0 time = 340
* CHECK dout0_1 vdout0_1ck33 = 0 time = 340
* CHECK dout0_2 vdout0_2ck33 = 0.9 time = 340
* CHECK dout0_3 vdout0_3ck33 = 0.9 time = 340
* CHECK dout0_4 vdout0_4ck33 = 0 time = 340
* CHECK dout0_5 vdout0_5ck33 = 0.9 time = 340
* CHECK dout0_6 vdout0_6ck33 = 0 time = 340
* CHECK dout0_7 vdout0_7ck33 = 0 time = 340
* CHECK dout0_0 vdout0_0ck35 = 0 time = 360
* CHECK dout0_1 vdout0_1ck35 = 0 time = 360
* CHECK dout0_2 vdout0_2ck35 = 0.9 time = 360
* CHECK dout0_3 vdout0_3ck35 = 0.9 time = 360
* CHECK dout0_4 vdout0_4ck35 = 0 time = 360
* CHECK dout0_5 vdout0_5ck35 = 0.9 time = 360
* CHECK dout0_6 vdout0_6ck35 = 0 time = 360
* CHECK dout0_7 vdout0_7ck35 = 0 time = 360
* CHECK dout0_0 vdout0_0ck37 = 0.9 time = 380
* CHECK dout0_1 vdout0_1ck37 = 0.9 time = 380
* CHECK dout0_2 vdout0_2ck37 = 0 time = 380
* CHECK dout0_3 vdout0_3ck37 = 0 time = 380
* CHECK dout0_4 vdout0_4ck37 = 0 time = 380
* CHECK dout0_5 vdout0_5ck37 = 0.9 time = 380
* CHECK dout0_6 vdout0_6ck37 = 0 time = 380
* CHECK dout0_7 vdout0_7ck37 = 0.9 time = 380
* CHECK dout0_0 vdout0_0ck38 = 0 time = 390
* CHECK dout0_1 vdout0_1ck38 = 0 time = 390
* CHECK dout0_2 vdout0_2ck38 = 0.9 time = 390
* CHECK dout0_3 vdout0_3ck38 = 0.9 time = 390
* CHECK dout0_4 vdout0_4ck38 = 0 time = 390
* CHECK dout0_5 vdout0_5ck38 = 0.9 time = 390
* CHECK dout0_6 vdout0_6ck38 = 0 time = 390
* CHECK dout0_7 vdout0_7ck38 = 0 time = 390
* CHECK dout0_0 vdout0_0ck39 = 0 time = 400
* CHECK dout0_1 vdout0_1ck39 = 0 time = 400
* CHECK dout0_2 vdout0_2ck39 = 0.9 time = 400
* CHECK dout0_3 vdout0_3ck39 = 0.9 time = 400
* CHECK dout0_4 vdout0_4ck39 = 0 time = 400
* CHECK dout0_5 vdout0_5ck39 = 0.9 time = 400
* CHECK dout0_6 vdout0_6ck39 = 0 time = 400
* CHECK dout0_7 vdout0_7ck39 = 0 time = 400
* CHECK dout0_0 vdout0_0ck43 = 0.9 time = 440
* CHECK dout0_1 vdout0_1ck43 = 0 time = 440
* CHECK dout0_2 vdout0_2ck43 = 0 time = 440
* CHECK dout0_3 vdout0_3ck43 = 0 time = 440
* CHECK dout0_4 vdout0_4ck43 = 0.9 time = 440
* CHECK dout0_5 vdout0_5ck43 = 0 time = 440
* CHECK dout0_6 vdout0_6ck43 = 0 time = 440
* CHECK dout0_7 vdout0_7ck43 = 0.9 time = 440
* CHECK dout0_0 vdout0_0ck44 = 0.9 time = 450
* CHECK dout0_1 vdout0_1ck44 = 0 time = 450
* CHECK dout0_2 vdout0_2ck44 = 0 time = 450
* CHECK dout0_3 vdout0_3ck44 = 0 time = 450
* CHECK dout0_4 vdout0_4ck44 = 0.9 time = 450
* CHECK dout0_5 vdout0_5ck44 = 0 time = 450
* CHECK dout0_6 vdout0_6ck44 = 0 time = 450
* CHECK dout0_7 vdout0_7ck44 = 0.9 time = 450
* CHECK dout0_0 vdout0_0ck47 = 0.9 time = 480
* CHECK dout0_1 vdout0_1ck47 = 0.9 time = 480
* CHECK dout0_2 vdout0_2ck47 = 0.9 time = 480
* CHECK dout0_3 vdout0_3ck47 = 0 time = 480
* CHECK dout0_4 vdout0_4ck47 = 0.9 time = 480
* CHECK dout0_5 vdout0_5ck47 = 0 time = 480
* CHECK dout0_6 vdout0_6ck47 = 0 time = 480
* CHECK dout0_7 vdout0_7ck47 = 0.9 time = 480
* CHECK dout0_0 vdout0_0ck48 = 0.9 time = 490
* CHECK dout0_1 vdout0_1ck48 = 0 time = 490
* CHECK dout0_2 vdout0_2ck48 = 0 time = 490
* CHECK dout0_3 vdout0_3ck48 = 0 time = 490
* CHECK dout0_4 vdout0_4ck48 = 0.9 time = 490
* CHECK dout0_5 vdout0_5ck48 = 0 time = 490
* CHECK dout0_6 vdout0_6ck48 = 0 time = 490
* CHECK dout0_7 vdout0_7ck48 = 0.9 time = 490
* CHECK dout0_0 vdout0_0ck52 = 0.9 time = 530
* CHECK dout0_1 vdout0_1ck52 = 0 time = 530
* CHECK dout0_2 vdout0_2ck52 = 0.9 time = 530
* CHECK dout0_3 vdout0_3ck52 = 0.9 time = 530
* CHECK dout0_4 vdout0_4ck52 = 0 time = 530
* CHECK dout0_5 vdout0_5ck52 = 0 time = 530
* CHECK dout0_6 vdout0_6ck52 = 0 time = 530
* CHECK dout0_7 vdout0_7ck52 = 0.9 time = 530
* CHECK dout0_0 vdout0_0ck57 = 0 time = 580
* CHECK dout0_1 vdout0_1ck57 = 0 time = 580
* CHECK dout0_2 vdout0_2ck57 = 0 time = 580
* CHECK dout0_3 vdout0_3ck57 = 0.9 time = 580
* CHECK dout0_4 vdout0_4ck57 = 0.9 time = 580
* CHECK dout0_5 vdout0_5ck57 = 0.9 time = 580
* CHECK dout0_6 vdout0_6ck57 = 0.9 time = 580
* CHECK dout0_7 vdout0_7ck57 = 0 time = 580
* CHECK dout0_0 vdout0_0ck58 = 0 time = 590
* CHECK dout0_1 vdout0_1ck58 = 0 time = 590
* CHECK dout0_2 vdout0_2ck58 = 0 time = 590
* CHECK dout0_3 vdout0_3ck58 = 0.9 time = 590
* CHECK dout0_4 vdout0_4ck58 = 0.9 time = 590
* CHECK dout0_5 vdout0_5ck58 = 0.9 time = 590
* CHECK dout0_6 vdout0_6ck58 = 0.9 time = 590
* CHECK dout0_7 vdout0_7ck58 = 0 time = 590
* CHECK dout0_0 vdout0_0ck59 = 0.9 time = 600
* CHECK dout0_1 vdout0_1ck59 = 0 time = 600
* CHECK dout0_2 vdout0_2ck59 = 0.9 time = 600
* CHECK dout0_3 vdout0_3ck59 = 0 time = 600
* CHECK dout0_4 vdout0_4ck59 = 0.9 time = 600
* CHECK dout0_5 vdout0_5ck59 = 0.9 time = 600
* CHECK dout0_6 vdout0_6ck59 = 0 time = 600
* CHECK dout0_7 vdout0_7ck59 = 0.9 time = 600
* CHECK dout0_0 vdout0_0ck60 = 0 time = 610
* CHECK dout0_1 vdout0_1ck60 = 0 time = 610
* CHECK dout0_2 vdout0_2ck60 = 0 time = 610
* CHECK dout0_3 vdout0_3ck60 = 0.9 time = 610
* CHECK dout0_4 vdout0_4ck60 = 0.9 time = 610
* CHECK dout0_5 vdout0_5ck60 = 0.9 time = 610
* CHECK dout0_6 vdout0_6ck60 = 0.9 time = 610
* CHECK dout0_7 vdout0_7ck60 = 0 time = 610
* CHECK dout0_0 vdout0_0ck62 = 0 time = 630
* CHECK dout0_1 vdout0_1ck62 = 0 time = 630
* CHECK dout0_2 vdout0_2ck62 = 0 time = 630
* CHECK dout0_3 vdout0_3ck62 = 0.9 time = 630
* CHECK dout0_4 vdout0_4ck62 = 0.9 time = 630
* CHECK dout0_5 vdout0_5ck62 = 0.9 time = 630
* CHECK dout0_6 vdout0_6ck62 = 0.9 time = 630
* CHECK dout0_7 vdout0_7ck62 = 0 time = 630
* CHECK dout0_0 vdout0_0ck72 = 0.9 time = 730
* CHECK dout0_1 vdout0_1ck72 = 0 time = 730
* CHECK dout0_2 vdout0_2ck72 = 0 time = 730
* CHECK dout0_3 vdout0_3ck72 = 0.9 time = 730
* CHECK dout0_4 vdout0_4ck72 = 0.9 time = 730
* CHECK dout0_5 vdout0_5ck72 = 0 time = 730
* CHECK dout0_6 vdout0_6ck72 = 0 time = 730
* CHECK dout0_7 vdout0_7ck72 = 0 time = 730
* CHECK dout0_0 vdout0_0ck74 = 0.9 time = 750
* CHECK dout0_1 vdout0_1ck74 = 0 time = 750
* CHECK dout0_2 vdout0_2ck74 = 0 time = 750
* CHECK dout0_3 vdout0_3ck74 = 0.9 time = 750
* CHECK dout0_4 vdout0_4ck74 = 0.9 time = 750
* CHECK dout0_5 vdout0_5ck74 = 0 time = 750
* CHECK dout0_6 vdout0_6ck74 = 0 time = 750
* CHECK dout0_7 vdout0_7ck74 = 0 time = 750
* CHECK dout0_0 vdout0_0ck75 = 0.9 time = 760
* CHECK dout0_1 vdout0_1ck75 = 0 time = 760
* CHECK dout0_2 vdout0_2ck75 = 0 time = 760
* CHECK dout0_3 vdout0_3ck75 = 0.9 time = 760
* CHECK dout0_4 vdout0_4ck75 = 0.9 time = 760
* CHECK dout0_5 vdout0_5ck75 = 0 time = 760
* CHECK dout0_6 vdout0_6ck75 = 0 time = 760
* CHECK dout0_7 vdout0_7ck75 = 0 time = 760
* CHECK dout0_0 vdout0_0ck77 = 0.9 time = 780
* CHECK dout0_1 vdout0_1ck77 = 0.9 time = 780
* CHECK dout0_2 vdout0_2ck77 = 0 time = 780
* CHECK dout0_3 vdout0_3ck77 = 0 time = 780
* CHECK dout0_4 vdout0_4ck77 = 0 time = 780
* CHECK dout0_5 vdout0_5ck77 = 0 time = 780
* CHECK dout0_6 vdout0_6ck77 = 0.9 time = 780
* CHECK dout0_7 vdout0_7ck77 = 0 time = 780
* CHECK dout0_0 vdout0_0ck78 = 0.9 time = 790
* CHECK dout0_1 vdout0_1ck78 = 0.9 time = 790
* CHECK dout0_2 vdout0_2ck78 = 0 time = 790
* CHECK dout0_3 vdout0_3ck78 = 0 time = 790
* CHECK dout0_4 vdout0_4ck78 = 0 time = 790
* CHECK dout0_5 vdout0_5ck78 = 0 time = 790
* CHECK dout0_6 vdout0_6ck78 = 0.9 time = 790
* CHECK dout0_7 vdout0_7ck78 = 0 time = 790
* CHECK dout0_0 vdout0_0ck82 = 0.9 time = 830
* CHECK dout0_1 vdout0_1ck82 = 0 time = 830
* CHECK dout0_2 vdout0_2ck82 = 0.9 time = 830
* CHECK dout0_3 vdout0_3ck82 = 0.9 time = 830
* CHECK dout0_4 vdout0_4ck82 = 0.9 time = 830
* CHECK dout0_5 vdout0_5ck82 = 0 time = 830
* CHECK dout0_6 vdout0_6ck82 = 0 time = 830
* CHECK dout0_7 vdout0_7ck82 = 0.9 time = 830
* CHECK dout0_0 vdout0_0ck83 = 0.9 time = 840
* CHECK dout0_1 vdout0_1ck83 = 0 time = 840
* CHECK dout0_2 vdout0_2ck83 = 0.9 time = 840
* CHECK dout0_3 vdout0_3ck83 = 0.9 time = 840
* CHECK dout0_4 vdout0_4ck83 = 0.9 time = 840
* CHECK dout0_5 vdout0_5ck83 = 0 time = 840
* CHECK dout0_6 vdout0_6ck83 = 0 time = 840
* CHECK dout0_7 vdout0_7ck83 = 0.9 time = 840
* CHECK dout0_0 vdout0_0ck87 = 0.9 time = 880
* CHECK dout0_1 vdout0_1ck87 = 0.9 time = 880
* CHECK dout0_2 vdout0_2ck87 = 0 time = 880
* CHECK dout0_3 vdout0_3ck87 = 0 time = 880
* CHECK dout0_4 vdout0_4ck87 = 0 time = 880
* CHECK dout0_5 vdout0_5ck87 = 0 time = 880
* CHECK dout0_6 vdout0_6ck87 = 0.9 time = 880
* CHECK dout0_7 vdout0_7ck87 = 0 time = 880
* CHECK dout0_0 vdout0_0ck90 = 0.9 time = 910
* CHECK dout0_1 vdout0_1ck90 = 0.9 time = 910
* CHECK dout0_2 vdout0_2ck90 = 0 time = 910
* CHECK dout0_3 vdout0_3ck90 = 0.9 time = 910
* CHECK dout0_4 vdout0_4ck90 = 0.9 time = 910
* CHECK dout0_5 vdout0_5ck90 = 0 time = 910
* CHECK dout0_6 vdout0_6ck90 = 0.9 time = 910
* CHECK dout0_7 vdout0_7ck90 = 0 time = 910
* CHECK dout0_0 vdout0_0ck93 = 0 time = 940
* CHECK dout0_1 vdout0_1ck93 = 0 time = 940
* CHECK dout0_2 vdout0_2ck93 = 0 time = 940
* CHECK dout0_3 vdout0_3ck93 = 0 time = 940
* CHECK dout0_4 vdout0_4ck93 = 0.9 time = 940
* CHECK dout0_5 vdout0_5ck93 = 0.9 time = 940
* CHECK dout0_6 vdout0_6ck93 = 0 time = 940
* CHECK dout0_7 vdout0_7ck93 = 0.9 time = 940
* CHECK dout0_0 vdout0_0ck95 = 0 time = 960
* CHECK dout0_1 vdout0_1ck95 = 0 time = 960
* CHECK dout0_2 vdout0_2ck95 = 0 time = 960
* CHECK dout0_3 vdout0_3ck95 = 0 time = 960
* CHECK dout0_4 vdout0_4ck95 = 0.9 time = 960
* CHECK dout0_5 vdout0_5ck95 = 0.9 time = 960
* CHECK dout0_6 vdout0_6ck95 = 0 time = 960
* CHECK dout0_7 vdout0_7ck95 = 0.9 time = 960
* CHECK dout0_0 vdout0_0ck97 = 0.9 time = 980
* CHECK dout0_1 vdout0_1ck97 = 0.9 time = 980
* CHECK dout0_2 vdout0_2ck97 = 0.9 time = 980
* CHECK dout0_3 vdout0_3ck97 = 0 time = 980
* CHECK dout0_4 vdout0_4ck97 = 0.9 time = 980
* CHECK dout0_5 vdout0_5ck97 = 0 time = 980
* CHECK dout0_6 vdout0_6ck97 = 0.9 time = 980
* CHECK dout0_7 vdout0_7ck97 = 0.9 time = 980
* CHECK dout0_0 vdout0_0ck98 = 0.9 time = 990
* CHECK dout0_1 vdout0_1ck98 = 0.9 time = 990
* CHECK dout0_2 vdout0_2ck98 = 0.9 time = 990
* CHECK dout0_3 vdout0_3ck98 = 0 time = 990
* CHECK dout0_4 vdout0_4ck98 = 0.9 time = 990
* CHECK dout0_5 vdout0_5ck98 = 0 time = 990
* CHECK dout0_6 vdout0_6ck98 = 0.9 time = 990
* CHECK dout0_7 vdout0_7ck98 = 0 time = 990
* CHECK dout0_0 vdout0_0ck104 = 0.9 time = 1050
* CHECK dout0_1 vdout0_1ck104 = 0 time = 1050
* CHECK dout0_2 vdout0_2ck104 = 0.9 time = 1050
* CHECK dout0_3 vdout0_3ck104 = 0.9 time = 1050
* CHECK dout0_4 vdout0_4ck104 = 0 time = 1050
* CHECK dout0_5 vdout0_5ck104 = 0 time = 1050
* CHECK dout0_6 vdout0_6ck104 = 0.9 time = 1050
* CHECK dout0_7 vdout0_7ck104 = 0.9 time = 1050
* CHECK dout0_0 vdout0_0ck105 = 0 time = 1060
* CHECK dout0_1 vdout0_1ck105 = 0.9 time = 1060
* CHECK dout0_2 vdout0_2ck105 = 0 time = 1060
* CHECK dout0_3 vdout0_3ck105 = 0.9 time = 1060
* CHECK dout0_4 vdout0_4ck105 = 0 time = 1060
* CHECK dout0_5 vdout0_5ck105 = 0 time = 1060
* CHECK dout0_6 vdout0_6ck105 = 0.9 time = 1060
* CHECK dout0_7 vdout0_7ck105 = 0.9 time = 1060
* CHECK dout0_0 vdout0_0ck107 = 0 time = 1080
* CHECK dout0_1 vdout0_1ck107 = 0.9 time = 1080
* CHECK dout0_2 vdout0_2ck107 = 0 time = 1080
* CHECK dout0_3 vdout0_3ck107 = 0.9 time = 1080
* CHECK dout0_4 vdout0_4ck107 = 0 time = 1080
* CHECK dout0_5 vdout0_5ck107 = 0 time = 1080
* CHECK dout0_6 vdout0_6ck107 = 0.9 time = 1080
* CHECK dout0_7 vdout0_7ck107 = 0.9 time = 1080
* CHECK dout0_0 vdout0_0ck109 = 0.9 time = 1100
* CHECK dout0_1 vdout0_1ck109 = 0.9 time = 1100
* CHECK dout0_2 vdout0_2ck109 = 0.9 time = 1100
* CHECK dout0_3 vdout0_3ck109 = 0.9 time = 1100
* CHECK dout0_4 vdout0_4ck109 = 0 time = 1100
* CHECK dout0_5 vdout0_5ck109 = 0 time = 1100
* CHECK dout0_6 vdout0_6ck109 = 0 time = 1100
* CHECK dout0_7 vdout0_7ck109 = 0 time = 1100
* CHECK dout0_0 vdout0_0ck110 = 0 time = 1110
* CHECK dout0_1 vdout0_1ck110 = 0.9 time = 1110
* CHECK dout0_2 vdout0_2ck110 = 0 time = 1110
* CHECK dout0_3 vdout0_3ck110 = 0.9 time = 1110
* CHECK dout0_4 vdout0_4ck110 = 0 time = 1110
* CHECK dout0_5 vdout0_5ck110 = 0 time = 1110
* CHECK dout0_6 vdout0_6ck110 = 0.9 time = 1110
* CHECK dout0_7 vdout0_7ck110 = 0.9 time = 1110
* CHECK dout0_0 vdout0_0ck111 = 0 time = 1120
* CHECK dout0_1 vdout0_1ck111 = 0.9 time = 1120
* CHECK dout0_2 vdout0_2ck111 = 0 time = 1120
* CHECK dout0_3 vdout0_3ck111 = 0.9 time = 1120
* CHECK dout0_4 vdout0_4ck111 = 0 time = 1120
* CHECK dout0_5 vdout0_5ck111 = 0 time = 1120
* CHECK dout0_6 vdout0_6ck111 = 0.9 time = 1120
* CHECK dout0_7 vdout0_7ck111 = 0.9 time = 1120
* CHECK dout0_0 vdout0_0ck112 = 0.9 time = 1130
* CHECK dout0_1 vdout0_1ck112 = 0.9 time = 1130
* CHECK dout0_2 vdout0_2ck112 = 0.9 time = 1130
* CHECK dout0_3 vdout0_3ck112 = 0.9 time = 1130
* CHECK dout0_4 vdout0_4ck112 = 0 time = 1130
* CHECK dout0_5 vdout0_5ck112 = 0 time = 1130
* CHECK dout0_6 vdout0_6ck112 = 0 time = 1130
* CHECK dout0_7 vdout0_7ck112 = 0 time = 1130
* CHECK dout0_0 vdout0_0ck113 = 0 time = 1140
* CHECK dout0_1 vdout0_1ck113 = 0.9 time = 1140
* CHECK dout0_2 vdout0_2ck113 = 0 time = 1140
* CHECK dout0_3 vdout0_3ck113 = 0.9 time = 1140
* CHECK dout0_4 vdout0_4ck113 = 0 time = 1140
* CHECK dout0_5 vdout0_5ck113 = 0 time = 1140
* CHECK dout0_6 vdout0_6ck113 = 0.9 time = 1140
* CHECK dout0_7 vdout0_7ck113 = 0.9 time = 1140
* CHECK dout0_0 vdout0_0ck114 = 0 time = 1150
* CHECK dout0_1 vdout0_1ck114 = 0.9 time = 1150
* CHECK dout0_2 vdout0_2ck114 = 0 time = 1150
* CHECK dout0_3 vdout0_3ck114 = 0.9 time = 1150
* CHECK dout0_4 vdout0_4ck114 = 0 time = 1150
* CHECK dout0_5 vdout0_5ck114 = 0 time = 1150
* CHECK dout0_6 vdout0_6ck114 = 0.9 time = 1150
* CHECK dout0_7 vdout0_7ck114 = 0.9 time = 1150
* CHECK dout0_0 vdout0_0ck115 = 0.9 time = 1160
* CHECK dout0_1 vdout0_1ck115 = 0.9 time = 1160
* CHECK dout0_2 vdout0_2ck115 = 0.9 time = 1160
* CHECK dout0_3 vdout0_3ck115 = 0.9 time = 1160
* CHECK dout0_4 vdout0_4ck115 = 0 time = 1160
* CHECK dout0_5 vdout0_5ck115 = 0 time = 1160
* CHECK dout0_6 vdout0_6ck115 = 0 time = 1160
* CHECK dout0_7 vdout0_7ck115 = 0 time = 1160
* CHECK dout0_0 vdout0_0ck116 = 0.9 time = 1170
* CHECK dout0_1 vdout0_1ck116 = 0.9 time = 1170
* CHECK dout0_2 vdout0_2ck116 = 0.9 time = 1170
* CHECK dout0_3 vdout0_3ck116 = 0.9 time = 1170
* CHECK dout0_4 vdout0_4ck116 = 0 time = 1170
* CHECK dout0_5 vdout0_5ck116 = 0 time = 1170
* CHECK dout0_6 vdout0_6ck116 = 0 time = 1170
* CHECK dout0_7 vdout0_7ck116 = 0 time = 1170
* CHECK dout0_0 vdout0_0ck118 = 0 time = 1190
* CHECK dout0_1 vdout0_1ck118 = 0.9 time = 1190
* CHECK dout0_2 vdout0_2ck118 = 0 time = 1190
* CHECK dout0_3 vdout0_3ck118 = 0.9 time = 1190
* CHECK dout0_4 vdout0_4ck118 = 0 time = 1190
* CHECK dout0_5 vdout0_5ck118 = 0 time = 1190
* CHECK dout0_6 vdout0_6ck118 = 0.9 time = 1190
* CHECK dout0_7 vdout0_7ck118 = 0.9 time = 1190
* CHECK dout0_0 vdout0_0ck119 = 0.9 time = 1200
* CHECK dout0_1 vdout0_1ck119 = 0.9 time = 1200
* CHECK dout0_2 vdout0_2ck119 = 0.9 time = 1200
* CHECK dout0_3 vdout0_3ck119 = 0.9 time = 1200
* CHECK dout0_4 vdout0_4ck119 = 0 time = 1200
* CHECK dout0_5 vdout0_5ck119 = 0 time = 1200
* CHECK dout0_6 vdout0_6ck119 = 0 time = 1200
* CHECK dout0_7 vdout0_7ck119 = 0 time = 1200
* CHECK dout0_0 vdout0_0ck121 = 0 time = 1220
* CHECK dout0_1 vdout0_1ck121 = 0.9 time = 1220
* CHECK dout0_2 vdout0_2ck121 = 0 time = 1220
* CHECK dout0_3 vdout0_3ck121 = 0.9 time = 1220
* CHECK dout0_4 vdout0_4ck121 = 0 time = 1220
* CHECK dout0_5 vdout0_5ck121 = 0 time = 1220
* CHECK dout0_6 vdout0_6ck121 = 0.9 time = 1220
* CHECK dout0_7 vdout0_7ck121 = 0.9 time = 1220
* CHECK dout0_0 vdout0_0ck126 = 0 time = 1270
* CHECK dout0_1 vdout0_1ck126 = 0 time = 1270
* CHECK dout0_2 vdout0_2ck126 = 0.9 time = 1270
* CHECK dout0_3 vdout0_3ck126 = 0.9 time = 1270
* CHECK dout0_4 vdout0_4ck126 = 0 time = 1270
* CHECK dout0_5 vdout0_5ck126 = 0 time = 1270
* CHECK dout0_6 vdout0_6ck126 = 0 time = 1270
* CHECK dout0_7 vdout0_7ck126 = 0.9 time = 1270
* CHECK dout0_0 vdout0_0ck134 = 0 time = 1350
* CHECK dout0_1 vdout0_1ck134 = 0 time = 1350
* CHECK dout0_2 vdout0_2ck134 = 0.9 time = 1350
* CHECK dout0_3 vdout0_3ck134 = 0 time = 1350
* CHECK dout0_4 vdout0_4ck134 = 0 time = 1350
* CHECK dout0_5 vdout0_5ck134 = 0.9 time = 1350
* CHECK dout0_6 vdout0_6ck134 = 0.9 time = 1350
* CHECK dout0_7 vdout0_7ck134 = 0.9 time = 1350
* CHECK dout0_0 vdout0_0ck136 = 0.9 time = 1370
* CHECK dout0_1 vdout0_1ck136 = 0 time = 1370
* CHECK dout0_2 vdout0_2ck136 = 0 time = 1370
* CHECK dout0_3 vdout0_3ck136 = 0 time = 1370
* CHECK dout0_4 vdout0_4ck136 = 0.9 time = 1370
* CHECK dout0_5 vdout0_5ck136 = 0.9 time = 1370
* CHECK dout0_6 vdout0_6ck136 = 0.9 time = 1370
* CHECK dout0_7 vdout0_7ck136 = 0.9 time = 1370
* CHECK dout0_0 vdout0_0ck139 = 0.9 time = 1400
* CHECK dout0_1 vdout0_1ck139 = 0 time = 1400
* CHECK dout0_2 vdout0_2ck139 = 0.9 time = 1400
* CHECK dout0_3 vdout0_3ck139 = 0 time = 1400
* CHECK dout0_4 vdout0_4ck139 = 0 time = 1400
* CHECK dout0_5 vdout0_5ck139 = 0.9 time = 1400
* CHECK dout0_6 vdout0_6ck139 = 0.9 time = 1400
* CHECK dout0_7 vdout0_7ck139 = 0 time = 1400
* CHECK dout0_0 vdout0_0ck140 = 0.9 time = 1410
* CHECK dout0_1 vdout0_1ck140 = 0 time = 1410
* CHECK dout0_2 vdout0_2ck140 = 0 time = 1410
* CHECK dout0_3 vdout0_3ck140 = 0 time = 1410
* CHECK dout0_4 vdout0_4ck140 = 0.9 time = 1410
* CHECK dout0_5 vdout0_5ck140 = 0.9 time = 1410
* CHECK dout0_6 vdout0_6ck140 = 0.9 time = 1410
* CHECK dout0_7 vdout0_7ck140 = 0.9 time = 1410
* CHECK dout0_0 vdout0_0ck142 = 0.9 time = 1430
* CHECK dout0_1 vdout0_1ck142 = 0 time = 1430
* CHECK dout0_2 vdout0_2ck142 = 0.9 time = 1430
* CHECK dout0_3 vdout0_3ck142 = 0 time = 1430
* CHECK dout0_4 vdout0_4ck142 = 0 time = 1430
* CHECK dout0_5 vdout0_5ck142 = 0.9 time = 1430
* CHECK dout0_6 vdout0_6ck142 = 0.9 time = 1430
* CHECK dout0_7 vdout0_7ck142 = 0 time = 1430
* CHECK dout0_0 vdout0_0ck143 = 0.9 time = 1440
* CHECK dout0_1 vdout0_1ck143 = 0 time = 1440
* CHECK dout0_2 vdout0_2ck143 = 0 time = 1440
* CHECK dout0_3 vdout0_3ck143 = 0 time = 1440
* CHECK dout0_4 vdout0_4ck143 = 0.9 time = 1440
* CHECK dout0_5 vdout0_5ck143 = 0.9 time = 1440
* CHECK dout0_6 vdout0_6ck143 = 0.9 time = 1440
* CHECK dout0_7 vdout0_7ck143 = 0.9 time = 1440
* CHECK dout0_0 vdout0_0ck144 = 0.9 time = 1450
* CHECK dout0_1 vdout0_1ck144 = 0 time = 1450
* CHECK dout0_2 vdout0_2ck144 = 0.9 time = 1450
* CHECK dout0_3 vdout0_3ck144 = 0 time = 1450
* CHECK dout0_4 vdout0_4ck144 = 0 time = 1450
* CHECK dout0_5 vdout0_5ck144 = 0.9 time = 1450
* CHECK dout0_6 vdout0_6ck144 = 0.9 time = 1450
* CHECK dout0_7 vdout0_7ck144 = 0 time = 1450
* CHECK dout0_0 vdout0_0ck145 = 0.9 time = 1460
* CHECK dout0_1 vdout0_1ck145 = 0 time = 1460
* CHECK dout0_2 vdout0_2ck145 = 0 time = 1460
* CHECK dout0_3 vdout0_3ck145 = 0 time = 1460
* CHECK dout0_4 vdout0_4ck145 = 0.9 time = 1460
* CHECK dout0_5 vdout0_5ck145 = 0.9 time = 1460
* CHECK dout0_6 vdout0_6ck145 = 0.9 time = 1460
* CHECK dout0_7 vdout0_7ck145 = 0.9 time = 1460
* CHECK dout0_0 vdout0_0ck148 = 0.9 time = 1490
* CHECK dout0_1 vdout0_1ck148 = 0.9 time = 1490
* CHECK dout0_2 vdout0_2ck148 = 0 time = 1490
* CHECK dout0_3 vdout0_3ck148 = 0.9 time = 1490
* CHECK dout0_4 vdout0_4ck148 = 0.9 time = 1490
* CHECK dout0_5 vdout0_5ck148 = 0 time = 1490
* CHECK dout0_6 vdout0_6ck148 = 0.9 time = 1490
* CHECK dout0_7 vdout0_7ck148 = 0.9 time = 1490
* CHECK dout0_0 vdout0_0ck149 = 0 time = 1500
* CHECK dout0_1 vdout0_1ck149 = 0.9 time = 1500
* CHECK dout0_2 vdout0_2ck149 = 0 time = 1500
* CHECK dout0_3 vdout0_3ck149 = 0.9 time = 1500
* CHECK dout0_4 vdout0_4ck149 = 0 time = 1500
* CHECK dout0_5 vdout0_5ck149 = 0 time = 1500
* CHECK dout0_6 vdout0_6ck149 = 0 time = 1500
* CHECK dout0_7 vdout0_7ck149 = 0 time = 1500
* CHECK dout0_0 vdout0_0ck150 = 0.9 time = 1510
* CHECK dout0_1 vdout0_1ck150 = 0.9 time = 1510
* CHECK dout0_2 vdout0_2ck150 = 0 time = 1510
* CHECK dout0_3 vdout0_3ck150 = 0.9 time = 1510
* CHECK dout0_4 vdout0_4ck150 = 0.9 time = 1510
* CHECK dout0_5 vdout0_5ck150 = 0 time = 1510
* CHECK dout0_6 vdout0_6ck150 = 0.9 time = 1510
* CHECK dout0_7 vdout0_7ck150 = 0.9 time = 1510
* CHECK dout0_0 vdout0_0ck151 = 0 time = 1520
* CHECK dout0_1 vdout0_1ck151 = 0.9 time = 1520
* CHECK dout0_2 vdout0_2ck151 = 0 time = 1520
* CHECK dout0_3 vdout0_3ck151 = 0.9 time = 1520
* CHECK dout0_4 vdout0_4ck151 = 0 time = 1520
* CHECK dout0_5 vdout0_5ck151 = 0 time = 1520
* CHECK dout0_6 vdout0_6ck151 = 0 time = 1520
* CHECK dout0_7 vdout0_7ck151 = 0 time = 1520
* CHECK dout0_0 vdout0_0ck152 = 0 time = 1530
* CHECK dout0_1 vdout0_1ck152 = 0.9 time = 1530
* CHECK dout0_2 vdout0_2ck152 = 0 time = 1530
* CHECK dout0_3 vdout0_3ck152 = 0.9 time = 1530
* CHECK dout0_4 vdout0_4ck152 = 0 time = 1530
* CHECK dout0_5 vdout0_5ck152 = 0 time = 1530
* CHECK dout0_6 vdout0_6ck152 = 0 time = 1530
* CHECK dout0_7 vdout0_7ck152 = 0 time = 1530
* CHECK dout0_0 vdout0_0ck156 = 0 time = 1570
* CHECK dout0_1 vdout0_1ck156 = 0.9 time = 1570
* CHECK dout0_2 vdout0_2ck156 = 0 time = 1570
* CHECK dout0_3 vdout0_3ck156 = 0.9 time = 1570
* CHECK dout0_4 vdout0_4ck156 = 0 time = 1570
* CHECK dout0_5 vdout0_5ck156 = 0 time = 1570
* CHECK dout0_6 vdout0_6ck156 = 0 time = 1570
* CHECK dout0_7 vdout0_7ck156 = 0 time = 1570
* CHECK dout0_0 vdout0_0ck157 = 0 time = 1580
* CHECK dout0_1 vdout0_1ck157 = 0.9 time = 1580
* CHECK dout0_2 vdout0_2ck157 = 0.9 time = 1580
* CHECK dout0_3 vdout0_3ck157 = 0 time = 1580
* CHECK dout0_4 vdout0_4ck157 = 0 time = 1580
* CHECK dout0_5 vdout0_5ck157 = 0.9 time = 1580
* CHECK dout0_6 vdout0_6ck157 = 0.9 time = 1580
* CHECK dout0_7 vdout0_7ck157 = 0 time = 1580
* CHECK dout0_0 vdout0_0ck158 = 0 time = 1590
* CHECK dout0_1 vdout0_1ck158 = 0.9 time = 1590
* CHECK dout0_2 vdout0_2ck158 = 0.9 time = 1590
* CHECK dout0_3 vdout0_3ck158 = 0 time = 1590
* CHECK dout0_4 vdout0_4ck158 = 0 time = 1590
* CHECK dout0_5 vdout0_5ck158 = 0.9 time = 1590
* CHECK dout0_6 vdout0_6ck158 = 0.9 time = 1590
* CHECK dout0_7 vdout0_7ck158 = 0 time = 1590
* CHECK dout0_0 vdout0_0ck159 = 0 time = 1600
* CHECK dout0_1 vdout0_1ck159 = 0.9 time = 1600
* CHECK dout0_2 vdout0_2ck159 = 0.9 time = 1600
* CHECK dout0_3 vdout0_3ck159 = 0 time = 1600
* CHECK dout0_4 vdout0_4ck159 = 0 time = 1600
* CHECK dout0_5 vdout0_5ck159 = 0.9 time = 1600
* CHECK dout0_6 vdout0_6ck159 = 0.9 time = 1600
* CHECK dout0_7 vdout0_7ck159 = 0 time = 1600
* CHECK dout0_0 vdout0_0ck160 = 0 time = 1610
* CHECK dout0_1 vdout0_1ck160 = 0.9 time = 1610
* CHECK dout0_2 vdout0_2ck160 = 0.9 time = 1610
* CHECK dout0_3 vdout0_3ck160 = 0 time = 1610
* CHECK dout0_4 vdout0_4ck160 = 0 time = 1610
* CHECK dout0_5 vdout0_5ck160 = 0.9 time = 1610
* CHECK dout0_6 vdout0_6ck160 = 0.9 time = 1610
* CHECK dout0_7 vdout0_7ck160 = 0 time = 1610
* CHECK dout0_0 vdout0_0ck163 = 0 time = 1640
* CHECK dout0_1 vdout0_1ck163 = 0.9 time = 1640
* CHECK dout0_2 vdout0_2ck163 = 0.9 time = 1640
* CHECK dout0_3 vdout0_3ck163 = 0.9 time = 1640
* CHECK dout0_4 vdout0_4ck163 = 0.9 time = 1640
* CHECK dout0_5 vdout0_5ck163 = 0.9 time = 1640
* CHECK dout0_6 vdout0_6ck163 = 0.9 time = 1640
* CHECK dout0_7 vdout0_7ck163 = 0 time = 1640
* CHECK dout0_0 vdout0_0ck165 = 0 time = 1660
* CHECK dout0_1 vdout0_1ck165 = 0.9 time = 1660
* CHECK dout0_2 vdout0_2ck165 = 0.9 time = 1660
* CHECK dout0_3 vdout0_3ck165 = 0.9 time = 1660
* CHECK dout0_4 vdout0_4ck165 = 0.9 time = 1660
* CHECK dout0_5 vdout0_5ck165 = 0.9 time = 1660
* CHECK dout0_6 vdout0_6ck165 = 0.9 time = 1660
* CHECK dout0_7 vdout0_7ck165 = 0 time = 1660
* CHECK dout0_0 vdout0_0ck166 = 0 time = 1670
* CHECK dout0_1 vdout0_1ck166 = 0.9 time = 1670
* CHECK dout0_2 vdout0_2ck166 = 0 time = 1670
* CHECK dout0_3 vdout0_3ck166 = 0.9 time = 1670
* CHECK dout0_4 vdout0_4ck166 = 0 time = 1670
* CHECK dout0_5 vdout0_5ck166 = 0 time = 1670
* CHECK dout0_6 vdout0_6ck166 = 0 time = 1670
* CHECK dout0_7 vdout0_7ck166 = 0 time = 1670
* CHECK dout0_0 vdout0_0ck168 = 0 time = 1690
* CHECK dout0_1 vdout0_1ck168 = 0.9 time = 1690
* CHECK dout0_2 vdout0_2ck168 = 0.9 time = 1690
* CHECK dout0_3 vdout0_3ck168 = 0.9 time = 1690
* CHECK dout0_4 vdout0_4ck168 = 0.9 time = 1690
* CHECK dout0_5 vdout0_5ck168 = 0.9 time = 1690
* CHECK dout0_6 vdout0_6ck168 = 0.9 time = 1690
* CHECK dout0_7 vdout0_7ck168 = 0 time = 1690
* CHECK dout0_0 vdout0_0ck169 = 0 time = 1700
* CHECK dout0_1 vdout0_1ck169 = 0.9 time = 1700
* CHECK dout0_2 vdout0_2ck169 = 0.9 time = 1700
* CHECK dout0_3 vdout0_3ck169 = 0.9 time = 1700
* CHECK dout0_4 vdout0_4ck169 = 0.9 time = 1700
* CHECK dout0_5 vdout0_5ck169 = 0.9 time = 1700
* CHECK dout0_6 vdout0_6ck169 = 0.9 time = 1700
* CHECK dout0_7 vdout0_7ck169 = 0 time = 1700
* CHECK dout0_0 vdout0_0ck171 = 0 time = 1720
* CHECK dout0_1 vdout0_1ck171 = 0.9 time = 1720
* CHECK dout0_2 vdout0_2ck171 = 0.9 time = 1720
* CHECK dout0_3 vdout0_3ck171 = 0.9 time = 1720
* CHECK dout0_4 vdout0_4ck171 = 0.9 time = 1720
* CHECK dout0_5 vdout0_5ck171 = 0.9 time = 1720
* CHECK dout0_6 vdout0_6ck171 = 0.9 time = 1720
* CHECK dout0_7 vdout0_7ck171 = 0 time = 1720
* CHECK dout0_0 vdout0_0ck175 = 0 time = 1760
* CHECK dout0_1 vdout0_1ck175 = 0.9 time = 1760
* CHECK dout0_2 vdout0_2ck175 = 0 time = 1760
* CHECK dout0_3 vdout0_3ck175 = 0.9 time = 1760
* CHECK dout0_4 vdout0_4ck175 = 0 time = 1760
* CHECK dout0_5 vdout0_5ck175 = 0 time = 1760
* CHECK dout0_6 vdout0_6ck175 = 0 time = 1760
* CHECK dout0_7 vdout0_7ck175 = 0 time = 1760
* CHECK dout0_0 vdout0_0ck176 = 0 time = 1770
* CHECK dout0_1 vdout0_1ck176 = 0.9 time = 1770
* CHECK dout0_2 vdout0_2ck176 = 0.9 time = 1770
* CHECK dout0_3 vdout0_3ck176 = 0.9 time = 1770
* CHECK dout0_4 vdout0_4ck176 = 0.9 time = 1770
* CHECK dout0_5 vdout0_5ck176 = 0.9 time = 1770
* CHECK dout0_6 vdout0_6ck176 = 0 time = 1770
* CHECK dout0_7 vdout0_7ck176 = 0 time = 1770
* CHECK dout0_0 vdout0_0ck179 = 0 time = 1800
* CHECK dout0_1 vdout0_1ck179 = 0.9 time = 1800
* CHECK dout0_2 vdout0_2ck179 = 0 time = 1800
* CHECK dout0_3 vdout0_3ck179 = 0.9 time = 1800
* CHECK dout0_4 vdout0_4ck179 = 0 time = 1800
* CHECK dout0_5 vdout0_5ck179 = 0 time = 1800
* CHECK dout0_6 vdout0_6ck179 = 0 time = 1800
* CHECK dout0_7 vdout0_7ck179 = 0 time = 1800
* CHECK dout0_0 vdout0_0ck180 = 0.9 time = 1810
* CHECK dout0_1 vdout0_1ck180 = 0.9 time = 1810
* CHECK dout0_2 vdout0_2ck180 = 0 time = 1810
* CHECK dout0_3 vdout0_3ck180 = 0 time = 1810
* CHECK dout0_4 vdout0_4ck180 = 0.9 time = 1810
* CHECK dout0_5 vdout0_5ck180 = 0 time = 1810
* CHECK dout0_6 vdout0_6ck180 = 0.9 time = 1810
* CHECK dout0_7 vdout0_7ck180 = 0.9 time = 1810
* CHECK dout0_0 vdout0_0ck182 = 0.9 time = 1830
* CHECK dout0_1 vdout0_1ck182 = 0.9 time = 1830
* CHECK dout0_2 vdout0_2ck182 = 0 time = 1830
* CHECK dout0_3 vdout0_3ck182 = 0 time = 1830
* CHECK dout0_4 vdout0_4ck182 = 0.9 time = 1830
* CHECK dout0_5 vdout0_5ck182 = 0 time = 1830
* CHECK dout0_6 vdout0_6ck182 = 0.9 time = 1830
* CHECK dout0_7 vdout0_7ck182 = 0.9 time = 1830
* CHECK dout0_0 vdout0_0ck183 = 0 time = 1840
* CHECK dout0_1 vdout0_1ck183 = 0.9 time = 1840
* CHECK dout0_2 vdout0_2ck183 = 0 time = 1840
* CHECK dout0_3 vdout0_3ck183 = 0.9 time = 1840
* CHECK dout0_4 vdout0_4ck183 = 0 time = 1840
* CHECK dout0_5 vdout0_5ck183 = 0 time = 1840
* CHECK dout0_6 vdout0_6ck183 = 0 time = 1840
* CHECK dout0_7 vdout0_7ck183 = 0 time = 1840
* CHECK dout0_0 vdout0_0ck184 = 0.9 time = 1850
* CHECK dout0_1 vdout0_1ck184 = 0.9 time = 1850
* CHECK dout0_2 vdout0_2ck184 = 0 time = 1850
* CHECK dout0_3 vdout0_3ck184 = 0 time = 1850
* CHECK dout0_4 vdout0_4ck184 = 0.9 time = 1850
* CHECK dout0_5 vdout0_5ck184 = 0 time = 1850
* CHECK dout0_6 vdout0_6ck184 = 0.9 time = 1850
* CHECK dout0_7 vdout0_7ck184 = 0.9 time = 1850
* CHECK dout0_0 vdout0_0ck186 = 0 time = 1870
* CHECK dout0_1 vdout0_1ck186 = 0.9 time = 1870
* CHECK dout0_2 vdout0_2ck186 = 0 time = 1870
* CHECK dout0_3 vdout0_3ck186 = 0.9 time = 1870
* CHECK dout0_4 vdout0_4ck186 = 0 time = 1870
* CHECK dout0_5 vdout0_5ck186 = 0 time = 1870
* CHECK dout0_6 vdout0_6ck186 = 0 time = 1870
* CHECK dout0_7 vdout0_7ck186 = 0 time = 1870
* CHECK dout0_0 vdout0_0ck187 = 0 time = 1880
* CHECK dout0_1 vdout0_1ck187 = 0.9 time = 1880
* CHECK dout0_2 vdout0_2ck187 = 0 time = 1880
* CHECK dout0_3 vdout0_3ck187 = 0.9 time = 1880
* CHECK dout0_4 vdout0_4ck187 = 0 time = 1880
* CHECK dout0_5 vdout0_5ck187 = 0 time = 1880
* CHECK dout0_6 vdout0_6ck187 = 0 time = 1880
* CHECK dout0_7 vdout0_7ck187 = 0 time = 1880
* CHECK dout0_0 vdout0_0ck188 = 0 time = 1890
* CHECK dout0_1 vdout0_1ck188 = 0.9 time = 1890
* CHECK dout0_2 vdout0_2ck188 = 0 time = 1890
* CHECK dout0_3 vdout0_3ck188 = 0.9 time = 1890
* CHECK dout0_4 vdout0_4ck188 = 0 time = 1890
* CHECK dout0_5 vdout0_5ck188 = 0 time = 1890
* CHECK dout0_6 vdout0_6ck188 = 0 time = 1890
* CHECK dout0_7 vdout0_7ck188 = 0 time = 1890
* CHECK dout0_0 vdout0_0ck190 = 0 time = 1910
* CHECK dout0_1 vdout0_1ck190 = 0.9 time = 1910
* CHECK dout0_2 vdout0_2ck190 = 0 time = 1910
* CHECK dout0_3 vdout0_3ck190 = 0 time = 1910
* CHECK dout0_4 vdout0_4ck190 = 0.9 time = 1910
* CHECK dout0_5 vdout0_5ck190 = 0.9 time = 1910
* CHECK dout0_6 vdout0_6ck190 = 0.9 time = 1910
* CHECK dout0_7 vdout0_7ck190 = 0 time = 1910
* CHECK dout0_0 vdout0_0ck195 = 0 time = 1960
* CHECK dout0_1 vdout0_1ck195 = 0 time = 1960
* CHECK dout0_2 vdout0_2ck195 = 0.9 time = 1960
* CHECK dout0_3 vdout0_3ck195 = 0 time = 1960
* CHECK dout0_4 vdout0_4ck195 = 0 time = 1960
* CHECK dout0_5 vdout0_5ck195 = 0.9 time = 1960
* CHECK dout0_6 vdout0_6ck195 = 0.9 time = 1960
* CHECK dout0_7 vdout0_7ck195 = 0.9 time = 1960
* CHECK dout0_0 vdout0_0ck196 = 0 time = 1970
* CHECK dout0_1 vdout0_1ck196 = 0 time = 1970
* CHECK dout0_2 vdout0_2ck196 = 0.9 time = 1970
* CHECK dout0_3 vdout0_3ck196 = 0 time = 1970
* CHECK dout0_4 vdout0_4ck196 = 0 time = 1970
* CHECK dout0_5 vdout0_5ck196 = 0.9 time = 1970
* CHECK dout0_6 vdout0_6ck196 = 0.9 time = 1970
* CHECK dout0_7 vdout0_7ck196 = 0.9 time = 1970
* CHECK dout0_0 vdout0_0ck197 = 0.9 time = 1980
* CHECK dout0_1 vdout0_1ck197 = 0.9 time = 1980
* CHECK dout0_2 vdout0_2ck197 = 0 time = 1980
* CHECK dout0_3 vdout0_3ck197 = 0 time = 1980
* CHECK dout0_4 vdout0_4ck197 = 0 time = 1980
* CHECK dout0_5 vdout0_5ck197 = 0 time = 1980
* CHECK dout0_6 vdout0_6ck197 = 0 time = 1980
* CHECK dout0_7 vdout0_7ck197 = 0.9 time = 1980
* CHECK dout0_0 vdout0_0ck199 = 0.9 time = 2000
* CHECK dout0_1 vdout0_1ck199 = 0.9 time = 2000
* CHECK dout0_2 vdout0_2ck199 = 0 time = 2000
* CHECK dout0_3 vdout0_3ck199 = 0 time = 2000
* CHECK dout0_4 vdout0_4ck199 = 0 time = 2000
* CHECK dout0_5 vdout0_5ck199 = 0 time = 2000
* CHECK dout0_6 vdout0_6ck199 = 0 time = 2000
* CHECK dout0_7 vdout0_7ck199 = 0.9 time = 2000
* CHECK dout0_0 vdout0_0ck200 = 0.9 time = 2010
* CHECK dout0_1 vdout0_1ck200 = 0.9 time = 2010
* CHECK dout0_2 vdout0_2ck200 = 0 time = 2010
* CHECK dout0_3 vdout0_3ck200 = 0 time = 2010
* CHECK dout0_4 vdout0_4ck200 = 0 time = 2010
* CHECK dout0_5 vdout0_5ck200 = 0 time = 2010
* CHECK dout0_6 vdout0_6ck200 = 0 time = 2010
* CHECK dout0_7 vdout0_7ck200 = 0.9 time = 2010
* CHECK dout0_0 vdout0_0ck201 = 0 time = 2020
* CHECK dout0_1 vdout0_1ck201 = 0 time = 2020
* CHECK dout0_2 vdout0_2ck201 = 0.9 time = 2020
* CHECK dout0_3 vdout0_3ck201 = 0 time = 2020
* CHECK dout0_4 vdout0_4ck201 = 0 time = 2020
* CHECK dout0_5 vdout0_5ck201 = 0.9 time = 2020
* CHECK dout0_6 vdout0_6ck201 = 0.9 time = 2020
* CHECK dout0_7 vdout0_7ck201 = 0.9 time = 2020
* CHECK dout0_0 vdout0_0ck203 = 0 time = 2040
* CHECK dout0_1 vdout0_1ck203 = 0 time = 2040
* CHECK dout0_2 vdout0_2ck203 = 0.9 time = 2040
* CHECK dout0_3 vdout0_3ck203 = 0 time = 2040
* CHECK dout0_4 vdout0_4ck203 = 0 time = 2040
* CHECK dout0_5 vdout0_5ck203 = 0.9 time = 2040
* CHECK dout0_6 vdout0_6ck203 = 0.9 time = 2040
* CHECK dout0_7 vdout0_7ck203 = 0.9 time = 2040
.include /home/odutra/OpenRAM/./functional_meas.sp
* probe is used for hspice/xa, while plot is used in ngspice
*.probe V(*)
*.plot V(*)
.end
